* 20x20 Two-Layer Backside PDN Model
* Total cells: 400   Total pads: 49
* Pad locations (first 8): (2,2), (2,5), (2,8), (2,11), (2,14), (2,17), (2,20), (5,2), ...
* Interface: 'Vout' (driven by Vsupply at 0.6 V)

*=========== Design Parameters ===========
.param Iload=32.36 PnTSV=4u tile=400u
.param Vout_dc=0.6
.param Pb=57u alpha=3 Pp=150u
.param hVia=10u Dvia=50u

*=========== Per-Layer Resistance ===========
.param Nbpr={tile/0.105u}
.param Nseg={tile/PnTSV}
.param Rbpr={50*PnTSV/12/(Nbpr*Nseg)}
.param NnTSV={(tile/PnTSV)*(tile/(2*0.105u))}
.param RnTSV={2/NnTSV}
.param Lbsm1={2*PnTSV}
.param RsegBSM1={80m*Lbsm1/0.5u}
.param NsegBSM1={(tile/PnTSV)*(tile/(2*PnTSV))}
.param Rbsm1={RsegBSM1/12/NsegBSM1}
.param RtapOne={0.5*(2u/PnTSV)**2}
.param Ntap={(tile/(2*PnTSV))**2}
.param Rtap={RtapOne/Ntap}
.param Nbump={(tile/Pb)**2}
.param Rbsm3={40m/4/Nbump}
.param Rbump={10m/Nbump}
.param wBus={Pb*(alpha+1)/alpha}
.param Nbus={tile/Pp}
.param Rrdl3={2m*tile/wBus/3/Nbus}
.param RviaOne={1.68e-8*hVia/(3.14159*(Dvia/2)**2)}
.param Rvia={RviaOne/Nbump}
.param Npillar={(tile/Pp)**2}
.param Rrdl2={2m*0.25/Npillar}
.param Rrdl1={2m*0.25/Npillar}
.param RpillarOne={1.68e-8*120u/(3.14159*(75u/2)**2)}
.param Rpillar={RpillarOne/Npillar}

*=========== Mesh Aggregate (20x20, 49 pads) ===========
.param Ncells=400
.param Rlat=40m
.param Rsup={(Rpillar+Rrdl1+2*Rvia+Rrdl2+Rrdl3+Rbump)*49}
.param Rvia_cell={Rtap*Ncells}

*=========== Upper Layer Horizontal Laterals ===========
RH_1_1 n_1_1_h n_1_2_h {Rlat}
RH_1_2 n_1_2_h n_1_3_h {Rlat}
RH_1_3 n_1_3_h n_1_4_h {Rlat}
RH_1_4 n_1_4_h n_1_5_h {Rlat}
RH_1_5 n_1_5_h n_1_6_h {Rlat}
RH_1_6 n_1_6_h n_1_7_h {Rlat}
RH_1_7 n_1_7_h n_1_8_h {Rlat}
RH_1_8 n_1_8_h n_1_9_h {Rlat}
RH_1_9 n_1_9_h n_1_10_h {Rlat}
RH_1_10 n_1_10_h n_1_11_h {Rlat}
RH_1_11 n_1_11_h n_1_12_h {Rlat}
RH_1_12 n_1_12_h n_1_13_h {Rlat}
RH_1_13 n_1_13_h n_1_14_h {Rlat}
RH_1_14 n_1_14_h n_1_15_h {Rlat}
RH_1_15 n_1_15_h n_1_16_h {Rlat}
RH_1_16 n_1_16_h n_1_17_h {Rlat}
RH_1_17 n_1_17_h n_1_18_h {Rlat}
RH_1_18 n_1_18_h n_1_19_h {Rlat}
RH_1_19 n_1_19_h n_1_20_h {Rlat}
RH_2_1 n_2_1_h n_2_2_h {Rlat}
RH_2_2 n_2_2_h n_2_3_h {Rlat}
RH_2_3 n_2_3_h n_2_4_h {Rlat}
RH_2_4 n_2_4_h n_2_5_h {Rlat}
RH_2_5 n_2_5_h n_2_6_h {Rlat}
RH_2_6 n_2_6_h n_2_7_h {Rlat}
RH_2_7 n_2_7_h n_2_8_h {Rlat}
RH_2_8 n_2_8_h n_2_9_h {Rlat}
RH_2_9 n_2_9_h n_2_10_h {Rlat}
RH_2_10 n_2_10_h n_2_11_h {Rlat}
RH_2_11 n_2_11_h n_2_12_h {Rlat}
RH_2_12 n_2_12_h n_2_13_h {Rlat}
RH_2_13 n_2_13_h n_2_14_h {Rlat}
RH_2_14 n_2_14_h n_2_15_h {Rlat}
RH_2_15 n_2_15_h n_2_16_h {Rlat}
RH_2_16 n_2_16_h n_2_17_h {Rlat}
RH_2_17 n_2_17_h n_2_18_h {Rlat}
RH_2_18 n_2_18_h n_2_19_h {Rlat}
RH_2_19 n_2_19_h n_2_20_h {Rlat}
RH_3_1 n_3_1_h n_3_2_h {Rlat}
RH_3_2 n_3_2_h n_3_3_h {Rlat}
RH_3_3 n_3_3_h n_3_4_h {Rlat}
RH_3_4 n_3_4_h n_3_5_h {Rlat}
RH_3_5 n_3_5_h n_3_6_h {Rlat}
RH_3_6 n_3_6_h n_3_7_h {Rlat}
RH_3_7 n_3_7_h n_3_8_h {Rlat}
RH_3_8 n_3_8_h n_3_9_h {Rlat}
RH_3_9 n_3_9_h n_3_10_h {Rlat}
RH_3_10 n_3_10_h n_3_11_h {Rlat}
RH_3_11 n_3_11_h n_3_12_h {Rlat}
RH_3_12 n_3_12_h n_3_13_h {Rlat}
RH_3_13 n_3_13_h n_3_14_h {Rlat}
RH_3_14 n_3_14_h n_3_15_h {Rlat}
RH_3_15 n_3_15_h n_3_16_h {Rlat}
RH_3_16 n_3_16_h n_3_17_h {Rlat}
RH_3_17 n_3_17_h n_3_18_h {Rlat}
RH_3_18 n_3_18_h n_3_19_h {Rlat}
RH_3_19 n_3_19_h n_3_20_h {Rlat}
RH_4_1 n_4_1_h n_4_2_h {Rlat}
RH_4_2 n_4_2_h n_4_3_h {Rlat}
RH_4_3 n_4_3_h n_4_4_h {Rlat}
RH_4_4 n_4_4_h n_4_5_h {Rlat}
RH_4_5 n_4_5_h n_4_6_h {Rlat}
RH_4_6 n_4_6_h n_4_7_h {Rlat}
RH_4_7 n_4_7_h n_4_8_h {Rlat}
RH_4_8 n_4_8_h n_4_9_h {Rlat}
RH_4_9 n_4_9_h n_4_10_h {Rlat}
RH_4_10 n_4_10_h n_4_11_h {Rlat}
RH_4_11 n_4_11_h n_4_12_h {Rlat}
RH_4_12 n_4_12_h n_4_13_h {Rlat}
RH_4_13 n_4_13_h n_4_14_h {Rlat}
RH_4_14 n_4_14_h n_4_15_h {Rlat}
RH_4_15 n_4_15_h n_4_16_h {Rlat}
RH_4_16 n_4_16_h n_4_17_h {Rlat}
RH_4_17 n_4_17_h n_4_18_h {Rlat}
RH_4_18 n_4_18_h n_4_19_h {Rlat}
RH_4_19 n_4_19_h n_4_20_h {Rlat}
RH_5_1 n_5_1_h n_5_2_h {Rlat}
RH_5_2 n_5_2_h n_5_3_h {Rlat}
RH_5_3 n_5_3_h n_5_4_h {Rlat}
RH_5_4 n_5_4_h n_5_5_h {Rlat}
RH_5_5 n_5_5_h n_5_6_h {Rlat}
RH_5_6 n_5_6_h n_5_7_h {Rlat}
RH_5_7 n_5_7_h n_5_8_h {Rlat}
RH_5_8 n_5_8_h n_5_9_h {Rlat}
RH_5_9 n_5_9_h n_5_10_h {Rlat}
RH_5_10 n_5_10_h n_5_11_h {Rlat}
RH_5_11 n_5_11_h n_5_12_h {Rlat}
RH_5_12 n_5_12_h n_5_13_h {Rlat}
RH_5_13 n_5_13_h n_5_14_h {Rlat}
RH_5_14 n_5_14_h n_5_15_h {Rlat}
RH_5_15 n_5_15_h n_5_16_h {Rlat}
RH_5_16 n_5_16_h n_5_17_h {Rlat}
RH_5_17 n_5_17_h n_5_18_h {Rlat}
RH_5_18 n_5_18_h n_5_19_h {Rlat}
RH_5_19 n_5_19_h n_5_20_h {Rlat}
RH_6_1 n_6_1_h n_6_2_h {Rlat}
RH_6_2 n_6_2_h n_6_3_h {Rlat}
RH_6_3 n_6_3_h n_6_4_h {Rlat}
RH_6_4 n_6_4_h n_6_5_h {Rlat}
RH_6_5 n_6_5_h n_6_6_h {Rlat}
RH_6_6 n_6_6_h n_6_7_h {Rlat}
RH_6_7 n_6_7_h n_6_8_h {Rlat}
RH_6_8 n_6_8_h n_6_9_h {Rlat}
RH_6_9 n_6_9_h n_6_10_h {Rlat}
RH_6_10 n_6_10_h n_6_11_h {Rlat}
RH_6_11 n_6_11_h n_6_12_h {Rlat}
RH_6_12 n_6_12_h n_6_13_h {Rlat}
RH_6_13 n_6_13_h n_6_14_h {Rlat}
RH_6_14 n_6_14_h n_6_15_h {Rlat}
RH_6_15 n_6_15_h n_6_16_h {Rlat}
RH_6_16 n_6_16_h n_6_17_h {Rlat}
RH_6_17 n_6_17_h n_6_18_h {Rlat}
RH_6_18 n_6_18_h n_6_19_h {Rlat}
RH_6_19 n_6_19_h n_6_20_h {Rlat}
RH_7_1 n_7_1_h n_7_2_h {Rlat}
RH_7_2 n_7_2_h n_7_3_h {Rlat}
RH_7_3 n_7_3_h n_7_4_h {Rlat}
RH_7_4 n_7_4_h n_7_5_h {Rlat}
RH_7_5 n_7_5_h n_7_6_h {Rlat}
RH_7_6 n_7_6_h n_7_7_h {Rlat}
RH_7_7 n_7_7_h n_7_8_h {Rlat}
RH_7_8 n_7_8_h n_7_9_h {Rlat}
RH_7_9 n_7_9_h n_7_10_h {Rlat}
RH_7_10 n_7_10_h n_7_11_h {Rlat}
RH_7_11 n_7_11_h n_7_12_h {Rlat}
RH_7_12 n_7_12_h n_7_13_h {Rlat}
RH_7_13 n_7_13_h n_7_14_h {Rlat}
RH_7_14 n_7_14_h n_7_15_h {Rlat}
RH_7_15 n_7_15_h n_7_16_h {Rlat}
RH_7_16 n_7_16_h n_7_17_h {Rlat}
RH_7_17 n_7_17_h n_7_18_h {Rlat}
RH_7_18 n_7_18_h n_7_19_h {Rlat}
RH_7_19 n_7_19_h n_7_20_h {Rlat}
RH_8_1 n_8_1_h n_8_2_h {Rlat}
RH_8_2 n_8_2_h n_8_3_h {Rlat}
RH_8_3 n_8_3_h n_8_4_h {Rlat}
RH_8_4 n_8_4_h n_8_5_h {Rlat}
RH_8_5 n_8_5_h n_8_6_h {Rlat}
RH_8_6 n_8_6_h n_8_7_h {Rlat}
RH_8_7 n_8_7_h n_8_8_h {Rlat}
RH_8_8 n_8_8_h n_8_9_h {Rlat}
RH_8_9 n_8_9_h n_8_10_h {Rlat}
RH_8_10 n_8_10_h n_8_11_h {Rlat}
RH_8_11 n_8_11_h n_8_12_h {Rlat}
RH_8_12 n_8_12_h n_8_13_h {Rlat}
RH_8_13 n_8_13_h n_8_14_h {Rlat}
RH_8_14 n_8_14_h n_8_15_h {Rlat}
RH_8_15 n_8_15_h n_8_16_h {Rlat}
RH_8_16 n_8_16_h n_8_17_h {Rlat}
RH_8_17 n_8_17_h n_8_18_h {Rlat}
RH_8_18 n_8_18_h n_8_19_h {Rlat}
RH_8_19 n_8_19_h n_8_20_h {Rlat}
RH_9_1 n_9_1_h n_9_2_h {Rlat}
RH_9_2 n_9_2_h n_9_3_h {Rlat}
RH_9_3 n_9_3_h n_9_4_h {Rlat}
RH_9_4 n_9_4_h n_9_5_h {Rlat}
RH_9_5 n_9_5_h n_9_6_h {Rlat}
RH_9_6 n_9_6_h n_9_7_h {Rlat}
RH_9_7 n_9_7_h n_9_8_h {Rlat}
RH_9_8 n_9_8_h n_9_9_h {Rlat}
RH_9_9 n_9_9_h n_9_10_h {Rlat}
RH_9_10 n_9_10_h n_9_11_h {Rlat}
RH_9_11 n_9_11_h n_9_12_h {Rlat}
RH_9_12 n_9_12_h n_9_13_h {Rlat}
RH_9_13 n_9_13_h n_9_14_h {Rlat}
RH_9_14 n_9_14_h n_9_15_h {Rlat}
RH_9_15 n_9_15_h n_9_16_h {Rlat}
RH_9_16 n_9_16_h n_9_17_h {Rlat}
RH_9_17 n_9_17_h n_9_18_h {Rlat}
RH_9_18 n_9_18_h n_9_19_h {Rlat}
RH_9_19 n_9_19_h n_9_20_h {Rlat}
RH_10_1 n_10_1_h n_10_2_h {Rlat}
RH_10_2 n_10_2_h n_10_3_h {Rlat}
RH_10_3 n_10_3_h n_10_4_h {Rlat}
RH_10_4 n_10_4_h n_10_5_h {Rlat}
RH_10_5 n_10_5_h n_10_6_h {Rlat}
RH_10_6 n_10_6_h n_10_7_h {Rlat}
RH_10_7 n_10_7_h n_10_8_h {Rlat}
RH_10_8 n_10_8_h n_10_9_h {Rlat}
RH_10_9 n_10_9_h n_10_10_h {Rlat}
RH_10_10 n_10_10_h n_10_11_h {Rlat}
RH_10_11 n_10_11_h n_10_12_h {Rlat}
RH_10_12 n_10_12_h n_10_13_h {Rlat}
RH_10_13 n_10_13_h n_10_14_h {Rlat}
RH_10_14 n_10_14_h n_10_15_h {Rlat}
RH_10_15 n_10_15_h n_10_16_h {Rlat}
RH_10_16 n_10_16_h n_10_17_h {Rlat}
RH_10_17 n_10_17_h n_10_18_h {Rlat}
RH_10_18 n_10_18_h n_10_19_h {Rlat}
RH_10_19 n_10_19_h n_10_20_h {Rlat}
RH_11_1 n_11_1_h n_11_2_h {Rlat}
RH_11_2 n_11_2_h n_11_3_h {Rlat}
RH_11_3 n_11_3_h n_11_4_h {Rlat}
RH_11_4 n_11_4_h n_11_5_h {Rlat}
RH_11_5 n_11_5_h n_11_6_h {Rlat}
RH_11_6 n_11_6_h n_11_7_h {Rlat}
RH_11_7 n_11_7_h n_11_8_h {Rlat}
RH_11_8 n_11_8_h n_11_9_h {Rlat}
RH_11_9 n_11_9_h n_11_10_h {Rlat}
RH_11_10 n_11_10_h n_11_11_h {Rlat}
RH_11_11 n_11_11_h n_11_12_h {Rlat}
RH_11_12 n_11_12_h n_11_13_h {Rlat}
RH_11_13 n_11_13_h n_11_14_h {Rlat}
RH_11_14 n_11_14_h n_11_15_h {Rlat}
RH_11_15 n_11_15_h n_11_16_h {Rlat}
RH_11_16 n_11_16_h n_11_17_h {Rlat}
RH_11_17 n_11_17_h n_11_18_h {Rlat}
RH_11_18 n_11_18_h n_11_19_h {Rlat}
RH_11_19 n_11_19_h n_11_20_h {Rlat}
RH_12_1 n_12_1_h n_12_2_h {Rlat}
RH_12_2 n_12_2_h n_12_3_h {Rlat}
RH_12_3 n_12_3_h n_12_4_h {Rlat}
RH_12_4 n_12_4_h n_12_5_h {Rlat}
RH_12_5 n_12_5_h n_12_6_h {Rlat}
RH_12_6 n_12_6_h n_12_7_h {Rlat}
RH_12_7 n_12_7_h n_12_8_h {Rlat}
RH_12_8 n_12_8_h n_12_9_h {Rlat}
RH_12_9 n_12_9_h n_12_10_h {Rlat}
RH_12_10 n_12_10_h n_12_11_h {Rlat}
RH_12_11 n_12_11_h n_12_12_h {Rlat}
RH_12_12 n_12_12_h n_12_13_h {Rlat}
RH_12_13 n_12_13_h n_12_14_h {Rlat}
RH_12_14 n_12_14_h n_12_15_h {Rlat}
RH_12_15 n_12_15_h n_12_16_h {Rlat}
RH_12_16 n_12_16_h n_12_17_h {Rlat}
RH_12_17 n_12_17_h n_12_18_h {Rlat}
RH_12_18 n_12_18_h n_12_19_h {Rlat}
RH_12_19 n_12_19_h n_12_20_h {Rlat}
RH_13_1 n_13_1_h n_13_2_h {Rlat}
RH_13_2 n_13_2_h n_13_3_h {Rlat}
RH_13_3 n_13_3_h n_13_4_h {Rlat}
RH_13_4 n_13_4_h n_13_5_h {Rlat}
RH_13_5 n_13_5_h n_13_6_h {Rlat}
RH_13_6 n_13_6_h n_13_7_h {Rlat}
RH_13_7 n_13_7_h n_13_8_h {Rlat}
RH_13_8 n_13_8_h n_13_9_h {Rlat}
RH_13_9 n_13_9_h n_13_10_h {Rlat}
RH_13_10 n_13_10_h n_13_11_h {Rlat}
RH_13_11 n_13_11_h n_13_12_h {Rlat}
RH_13_12 n_13_12_h n_13_13_h {Rlat}
RH_13_13 n_13_13_h n_13_14_h {Rlat}
RH_13_14 n_13_14_h n_13_15_h {Rlat}
RH_13_15 n_13_15_h n_13_16_h {Rlat}
RH_13_16 n_13_16_h n_13_17_h {Rlat}
RH_13_17 n_13_17_h n_13_18_h {Rlat}
RH_13_18 n_13_18_h n_13_19_h {Rlat}
RH_13_19 n_13_19_h n_13_20_h {Rlat}
RH_14_1 n_14_1_h n_14_2_h {Rlat}
RH_14_2 n_14_2_h n_14_3_h {Rlat}
RH_14_3 n_14_3_h n_14_4_h {Rlat}
RH_14_4 n_14_4_h n_14_5_h {Rlat}
RH_14_5 n_14_5_h n_14_6_h {Rlat}
RH_14_6 n_14_6_h n_14_7_h {Rlat}
RH_14_7 n_14_7_h n_14_8_h {Rlat}
RH_14_8 n_14_8_h n_14_9_h {Rlat}
RH_14_9 n_14_9_h n_14_10_h {Rlat}
RH_14_10 n_14_10_h n_14_11_h {Rlat}
RH_14_11 n_14_11_h n_14_12_h {Rlat}
RH_14_12 n_14_12_h n_14_13_h {Rlat}
RH_14_13 n_14_13_h n_14_14_h {Rlat}
RH_14_14 n_14_14_h n_14_15_h {Rlat}
RH_14_15 n_14_15_h n_14_16_h {Rlat}
RH_14_16 n_14_16_h n_14_17_h {Rlat}
RH_14_17 n_14_17_h n_14_18_h {Rlat}
RH_14_18 n_14_18_h n_14_19_h {Rlat}
RH_14_19 n_14_19_h n_14_20_h {Rlat}
RH_15_1 n_15_1_h n_15_2_h {Rlat}
RH_15_2 n_15_2_h n_15_3_h {Rlat}
RH_15_3 n_15_3_h n_15_4_h {Rlat}
RH_15_4 n_15_4_h n_15_5_h {Rlat}
RH_15_5 n_15_5_h n_15_6_h {Rlat}
RH_15_6 n_15_6_h n_15_7_h {Rlat}
RH_15_7 n_15_7_h n_15_8_h {Rlat}
RH_15_8 n_15_8_h n_15_9_h {Rlat}
RH_15_9 n_15_9_h n_15_10_h {Rlat}
RH_15_10 n_15_10_h n_15_11_h {Rlat}
RH_15_11 n_15_11_h n_15_12_h {Rlat}
RH_15_12 n_15_12_h n_15_13_h {Rlat}
RH_15_13 n_15_13_h n_15_14_h {Rlat}
RH_15_14 n_15_14_h n_15_15_h {Rlat}
RH_15_15 n_15_15_h n_15_16_h {Rlat}
RH_15_16 n_15_16_h n_15_17_h {Rlat}
RH_15_17 n_15_17_h n_15_18_h {Rlat}
RH_15_18 n_15_18_h n_15_19_h {Rlat}
RH_15_19 n_15_19_h n_15_20_h {Rlat}
RH_16_1 n_16_1_h n_16_2_h {Rlat}
RH_16_2 n_16_2_h n_16_3_h {Rlat}
RH_16_3 n_16_3_h n_16_4_h {Rlat}
RH_16_4 n_16_4_h n_16_5_h {Rlat}
RH_16_5 n_16_5_h n_16_6_h {Rlat}
RH_16_6 n_16_6_h n_16_7_h {Rlat}
RH_16_7 n_16_7_h n_16_8_h {Rlat}
RH_16_8 n_16_8_h n_16_9_h {Rlat}
RH_16_9 n_16_9_h n_16_10_h {Rlat}
RH_16_10 n_16_10_h n_16_11_h {Rlat}
RH_16_11 n_16_11_h n_16_12_h {Rlat}
RH_16_12 n_16_12_h n_16_13_h {Rlat}
RH_16_13 n_16_13_h n_16_14_h {Rlat}
RH_16_14 n_16_14_h n_16_15_h {Rlat}
RH_16_15 n_16_15_h n_16_16_h {Rlat}
RH_16_16 n_16_16_h n_16_17_h {Rlat}
RH_16_17 n_16_17_h n_16_18_h {Rlat}
RH_16_18 n_16_18_h n_16_19_h {Rlat}
RH_16_19 n_16_19_h n_16_20_h {Rlat}
RH_17_1 n_17_1_h n_17_2_h {Rlat}
RH_17_2 n_17_2_h n_17_3_h {Rlat}
RH_17_3 n_17_3_h n_17_4_h {Rlat}
RH_17_4 n_17_4_h n_17_5_h {Rlat}
RH_17_5 n_17_5_h n_17_6_h {Rlat}
RH_17_6 n_17_6_h n_17_7_h {Rlat}
RH_17_7 n_17_7_h n_17_8_h {Rlat}
RH_17_8 n_17_8_h n_17_9_h {Rlat}
RH_17_9 n_17_9_h n_17_10_h {Rlat}
RH_17_10 n_17_10_h n_17_11_h {Rlat}
RH_17_11 n_17_11_h n_17_12_h {Rlat}
RH_17_12 n_17_12_h n_17_13_h {Rlat}
RH_17_13 n_17_13_h n_17_14_h {Rlat}
RH_17_14 n_17_14_h n_17_15_h {Rlat}
RH_17_15 n_17_15_h n_17_16_h {Rlat}
RH_17_16 n_17_16_h n_17_17_h {Rlat}
RH_17_17 n_17_17_h n_17_18_h {Rlat}
RH_17_18 n_17_18_h n_17_19_h {Rlat}
RH_17_19 n_17_19_h n_17_20_h {Rlat}
RH_18_1 n_18_1_h n_18_2_h {Rlat}
RH_18_2 n_18_2_h n_18_3_h {Rlat}
RH_18_3 n_18_3_h n_18_4_h {Rlat}
RH_18_4 n_18_4_h n_18_5_h {Rlat}
RH_18_5 n_18_5_h n_18_6_h {Rlat}
RH_18_6 n_18_6_h n_18_7_h {Rlat}
RH_18_7 n_18_7_h n_18_8_h {Rlat}
RH_18_8 n_18_8_h n_18_9_h {Rlat}
RH_18_9 n_18_9_h n_18_10_h {Rlat}
RH_18_10 n_18_10_h n_18_11_h {Rlat}
RH_18_11 n_18_11_h n_18_12_h {Rlat}
RH_18_12 n_18_12_h n_18_13_h {Rlat}
RH_18_13 n_18_13_h n_18_14_h {Rlat}
RH_18_14 n_18_14_h n_18_15_h {Rlat}
RH_18_15 n_18_15_h n_18_16_h {Rlat}
RH_18_16 n_18_16_h n_18_17_h {Rlat}
RH_18_17 n_18_17_h n_18_18_h {Rlat}
RH_18_18 n_18_18_h n_18_19_h {Rlat}
RH_18_19 n_18_19_h n_18_20_h {Rlat}
RH_19_1 n_19_1_h n_19_2_h {Rlat}
RH_19_2 n_19_2_h n_19_3_h {Rlat}
RH_19_3 n_19_3_h n_19_4_h {Rlat}
RH_19_4 n_19_4_h n_19_5_h {Rlat}
RH_19_5 n_19_5_h n_19_6_h {Rlat}
RH_19_6 n_19_6_h n_19_7_h {Rlat}
RH_19_7 n_19_7_h n_19_8_h {Rlat}
RH_19_8 n_19_8_h n_19_9_h {Rlat}
RH_19_9 n_19_9_h n_19_10_h {Rlat}
RH_19_10 n_19_10_h n_19_11_h {Rlat}
RH_19_11 n_19_11_h n_19_12_h {Rlat}
RH_19_12 n_19_12_h n_19_13_h {Rlat}
RH_19_13 n_19_13_h n_19_14_h {Rlat}
RH_19_14 n_19_14_h n_19_15_h {Rlat}
RH_19_15 n_19_15_h n_19_16_h {Rlat}
RH_19_16 n_19_16_h n_19_17_h {Rlat}
RH_19_17 n_19_17_h n_19_18_h {Rlat}
RH_19_18 n_19_18_h n_19_19_h {Rlat}
RH_19_19 n_19_19_h n_19_20_h {Rlat}
RH_20_1 n_20_1_h n_20_2_h {Rlat}
RH_20_2 n_20_2_h n_20_3_h {Rlat}
RH_20_3 n_20_3_h n_20_4_h {Rlat}
RH_20_4 n_20_4_h n_20_5_h {Rlat}
RH_20_5 n_20_5_h n_20_6_h {Rlat}
RH_20_6 n_20_6_h n_20_7_h {Rlat}
RH_20_7 n_20_7_h n_20_8_h {Rlat}
RH_20_8 n_20_8_h n_20_9_h {Rlat}
RH_20_9 n_20_9_h n_20_10_h {Rlat}
RH_20_10 n_20_10_h n_20_11_h {Rlat}
RH_20_11 n_20_11_h n_20_12_h {Rlat}
RH_20_12 n_20_12_h n_20_13_h {Rlat}
RH_20_13 n_20_13_h n_20_14_h {Rlat}
RH_20_14 n_20_14_h n_20_15_h {Rlat}
RH_20_15 n_20_15_h n_20_16_h {Rlat}
RH_20_16 n_20_16_h n_20_17_h {Rlat}
RH_20_17 n_20_17_h n_20_18_h {Rlat}
RH_20_18 n_20_18_h n_20_19_h {Rlat}
RH_20_19 n_20_19_h n_20_20_h {Rlat}

*=========== Lower Layer Vertical Laterals ===========
RV_1_1 n_1_1 n_2_1 {Rlat}
RV_1_2 n_1_2 n_2_2 {Rlat}
RV_1_3 n_1_3 n_2_3 {Rlat}
RV_1_4 n_1_4 n_2_4 {Rlat}
RV_1_5 n_1_5 n_2_5 {Rlat}
RV_1_6 n_1_6 n_2_6 {Rlat}
RV_1_7 n_1_7 n_2_7 {Rlat}
RV_1_8 n_1_8 n_2_8 {Rlat}
RV_1_9 n_1_9 n_2_9 {Rlat}
RV_1_10 n_1_10 n_2_10 {Rlat}
RV_1_11 n_1_11 n_2_11 {Rlat}
RV_1_12 n_1_12 n_2_12 {Rlat}
RV_1_13 n_1_13 n_2_13 {Rlat}
RV_1_14 n_1_14 n_2_14 {Rlat}
RV_1_15 n_1_15 n_2_15 {Rlat}
RV_1_16 n_1_16 n_2_16 {Rlat}
RV_1_17 n_1_17 n_2_17 {Rlat}
RV_1_18 n_1_18 n_2_18 {Rlat}
RV_1_19 n_1_19 n_2_19 {Rlat}
RV_1_20 n_1_20 n_2_20 {Rlat}
RV_2_1 n_2_1 n_3_1 {Rlat}
RV_2_2 n_2_2 n_3_2 {Rlat}
RV_2_3 n_2_3 n_3_3 {Rlat}
RV_2_4 n_2_4 n_3_4 {Rlat}
RV_2_5 n_2_5 n_3_5 {Rlat}
RV_2_6 n_2_6 n_3_6 {Rlat}
RV_2_7 n_2_7 n_3_7 {Rlat}
RV_2_8 n_2_8 n_3_8 {Rlat}
RV_2_9 n_2_9 n_3_9 {Rlat}
RV_2_10 n_2_10 n_3_10 {Rlat}
RV_2_11 n_2_11 n_3_11 {Rlat}
RV_2_12 n_2_12 n_3_12 {Rlat}
RV_2_13 n_2_13 n_3_13 {Rlat}
RV_2_14 n_2_14 n_3_14 {Rlat}
RV_2_15 n_2_15 n_3_15 {Rlat}
RV_2_16 n_2_16 n_3_16 {Rlat}
RV_2_17 n_2_17 n_3_17 {Rlat}
RV_2_18 n_2_18 n_3_18 {Rlat}
RV_2_19 n_2_19 n_3_19 {Rlat}
RV_2_20 n_2_20 n_3_20 {Rlat}
RV_3_1 n_3_1 n_4_1 {Rlat}
RV_3_2 n_3_2 n_4_2 {Rlat}
RV_3_3 n_3_3 n_4_3 {Rlat}
RV_3_4 n_3_4 n_4_4 {Rlat}
RV_3_5 n_3_5 n_4_5 {Rlat}
RV_3_6 n_3_6 n_4_6 {Rlat}
RV_3_7 n_3_7 n_4_7 {Rlat}
RV_3_8 n_3_8 n_4_8 {Rlat}
RV_3_9 n_3_9 n_4_9 {Rlat}
RV_3_10 n_3_10 n_4_10 {Rlat}
RV_3_11 n_3_11 n_4_11 {Rlat}
RV_3_12 n_3_12 n_4_12 {Rlat}
RV_3_13 n_3_13 n_4_13 {Rlat}
RV_3_14 n_3_14 n_4_14 {Rlat}
RV_3_15 n_3_15 n_4_15 {Rlat}
RV_3_16 n_3_16 n_4_16 {Rlat}
RV_3_17 n_3_17 n_4_17 {Rlat}
RV_3_18 n_3_18 n_4_18 {Rlat}
RV_3_19 n_3_19 n_4_19 {Rlat}
RV_3_20 n_3_20 n_4_20 {Rlat}
RV_4_1 n_4_1 n_5_1 {Rlat}
RV_4_2 n_4_2 n_5_2 {Rlat}
RV_4_3 n_4_3 n_5_3 {Rlat}
RV_4_4 n_4_4 n_5_4 {Rlat}
RV_4_5 n_4_5 n_5_5 {Rlat}
RV_4_6 n_4_6 n_5_6 {Rlat}
RV_4_7 n_4_7 n_5_7 {Rlat}
RV_4_8 n_4_8 n_5_8 {Rlat}
RV_4_9 n_4_9 n_5_9 {Rlat}
RV_4_10 n_4_10 n_5_10 {Rlat}
RV_4_11 n_4_11 n_5_11 {Rlat}
RV_4_12 n_4_12 n_5_12 {Rlat}
RV_4_13 n_4_13 n_5_13 {Rlat}
RV_4_14 n_4_14 n_5_14 {Rlat}
RV_4_15 n_4_15 n_5_15 {Rlat}
RV_4_16 n_4_16 n_5_16 {Rlat}
RV_4_17 n_4_17 n_5_17 {Rlat}
RV_4_18 n_4_18 n_5_18 {Rlat}
RV_4_19 n_4_19 n_5_19 {Rlat}
RV_4_20 n_4_20 n_5_20 {Rlat}
RV_5_1 n_5_1 n_6_1 {Rlat}
RV_5_2 n_5_2 n_6_2 {Rlat}
RV_5_3 n_5_3 n_6_3 {Rlat}
RV_5_4 n_5_4 n_6_4 {Rlat}
RV_5_5 n_5_5 n_6_5 {Rlat}
RV_5_6 n_5_6 n_6_6 {Rlat}
RV_5_7 n_5_7 n_6_7 {Rlat}
RV_5_8 n_5_8 n_6_8 {Rlat}
RV_5_9 n_5_9 n_6_9 {Rlat}
RV_5_10 n_5_10 n_6_10 {Rlat}
RV_5_11 n_5_11 n_6_11 {Rlat}
RV_5_12 n_5_12 n_6_12 {Rlat}
RV_5_13 n_5_13 n_6_13 {Rlat}
RV_5_14 n_5_14 n_6_14 {Rlat}
RV_5_15 n_5_15 n_6_15 {Rlat}
RV_5_16 n_5_16 n_6_16 {Rlat}
RV_5_17 n_5_17 n_6_17 {Rlat}
RV_5_18 n_5_18 n_6_18 {Rlat}
RV_5_19 n_5_19 n_6_19 {Rlat}
RV_5_20 n_5_20 n_6_20 {Rlat}
RV_6_1 n_6_1 n_7_1 {Rlat}
RV_6_2 n_6_2 n_7_2 {Rlat}
RV_6_3 n_6_3 n_7_3 {Rlat}
RV_6_4 n_6_4 n_7_4 {Rlat}
RV_6_5 n_6_5 n_7_5 {Rlat}
RV_6_6 n_6_6 n_7_6 {Rlat}
RV_6_7 n_6_7 n_7_7 {Rlat}
RV_6_8 n_6_8 n_7_8 {Rlat}
RV_6_9 n_6_9 n_7_9 {Rlat}
RV_6_10 n_6_10 n_7_10 {Rlat}
RV_6_11 n_6_11 n_7_11 {Rlat}
RV_6_12 n_6_12 n_7_12 {Rlat}
RV_6_13 n_6_13 n_7_13 {Rlat}
RV_6_14 n_6_14 n_7_14 {Rlat}
RV_6_15 n_6_15 n_7_15 {Rlat}
RV_6_16 n_6_16 n_7_16 {Rlat}
RV_6_17 n_6_17 n_7_17 {Rlat}
RV_6_18 n_6_18 n_7_18 {Rlat}
RV_6_19 n_6_19 n_7_19 {Rlat}
RV_6_20 n_6_20 n_7_20 {Rlat}
RV_7_1 n_7_1 n_8_1 {Rlat}
RV_7_2 n_7_2 n_8_2 {Rlat}
RV_7_3 n_7_3 n_8_3 {Rlat}
RV_7_4 n_7_4 n_8_4 {Rlat}
RV_7_5 n_7_5 n_8_5 {Rlat}
RV_7_6 n_7_6 n_8_6 {Rlat}
RV_7_7 n_7_7 n_8_7 {Rlat}
RV_7_8 n_7_8 n_8_8 {Rlat}
RV_7_9 n_7_9 n_8_9 {Rlat}
RV_7_10 n_7_10 n_8_10 {Rlat}
RV_7_11 n_7_11 n_8_11 {Rlat}
RV_7_12 n_7_12 n_8_12 {Rlat}
RV_7_13 n_7_13 n_8_13 {Rlat}
RV_7_14 n_7_14 n_8_14 {Rlat}
RV_7_15 n_7_15 n_8_15 {Rlat}
RV_7_16 n_7_16 n_8_16 {Rlat}
RV_7_17 n_7_17 n_8_17 {Rlat}
RV_7_18 n_7_18 n_8_18 {Rlat}
RV_7_19 n_7_19 n_8_19 {Rlat}
RV_7_20 n_7_20 n_8_20 {Rlat}
RV_8_1 n_8_1 n_9_1 {Rlat}
RV_8_2 n_8_2 n_9_2 {Rlat}
RV_8_3 n_8_3 n_9_3 {Rlat}
RV_8_4 n_8_4 n_9_4 {Rlat}
RV_8_5 n_8_5 n_9_5 {Rlat}
RV_8_6 n_8_6 n_9_6 {Rlat}
RV_8_7 n_8_7 n_9_7 {Rlat}
RV_8_8 n_8_8 n_9_8 {Rlat}
RV_8_9 n_8_9 n_9_9 {Rlat}
RV_8_10 n_8_10 n_9_10 {Rlat}
RV_8_11 n_8_11 n_9_11 {Rlat}
RV_8_12 n_8_12 n_9_12 {Rlat}
RV_8_13 n_8_13 n_9_13 {Rlat}
RV_8_14 n_8_14 n_9_14 {Rlat}
RV_8_15 n_8_15 n_9_15 {Rlat}
RV_8_16 n_8_16 n_9_16 {Rlat}
RV_8_17 n_8_17 n_9_17 {Rlat}
RV_8_18 n_8_18 n_9_18 {Rlat}
RV_8_19 n_8_19 n_9_19 {Rlat}
RV_8_20 n_8_20 n_9_20 {Rlat}
RV_9_1 n_9_1 n_10_1 {Rlat}
RV_9_2 n_9_2 n_10_2 {Rlat}
RV_9_3 n_9_3 n_10_3 {Rlat}
RV_9_4 n_9_4 n_10_4 {Rlat}
RV_9_5 n_9_5 n_10_5 {Rlat}
RV_9_6 n_9_6 n_10_6 {Rlat}
RV_9_7 n_9_7 n_10_7 {Rlat}
RV_9_8 n_9_8 n_10_8 {Rlat}
RV_9_9 n_9_9 n_10_9 {Rlat}
RV_9_10 n_9_10 n_10_10 {Rlat}
RV_9_11 n_9_11 n_10_11 {Rlat}
RV_9_12 n_9_12 n_10_12 {Rlat}
RV_9_13 n_9_13 n_10_13 {Rlat}
RV_9_14 n_9_14 n_10_14 {Rlat}
RV_9_15 n_9_15 n_10_15 {Rlat}
RV_9_16 n_9_16 n_10_16 {Rlat}
RV_9_17 n_9_17 n_10_17 {Rlat}
RV_9_18 n_9_18 n_10_18 {Rlat}
RV_9_19 n_9_19 n_10_19 {Rlat}
RV_9_20 n_9_20 n_10_20 {Rlat}
RV_10_1 n_10_1 n_11_1 {Rlat}
RV_10_2 n_10_2 n_11_2 {Rlat}
RV_10_3 n_10_3 n_11_3 {Rlat}
RV_10_4 n_10_4 n_11_4 {Rlat}
RV_10_5 n_10_5 n_11_5 {Rlat}
RV_10_6 n_10_6 n_11_6 {Rlat}
RV_10_7 n_10_7 n_11_7 {Rlat}
RV_10_8 n_10_8 n_11_8 {Rlat}
RV_10_9 n_10_9 n_11_9 {Rlat}
RV_10_10 n_10_10 n_11_10 {Rlat}
RV_10_11 n_10_11 n_11_11 {Rlat}
RV_10_12 n_10_12 n_11_12 {Rlat}
RV_10_13 n_10_13 n_11_13 {Rlat}
RV_10_14 n_10_14 n_11_14 {Rlat}
RV_10_15 n_10_15 n_11_15 {Rlat}
RV_10_16 n_10_16 n_11_16 {Rlat}
RV_10_17 n_10_17 n_11_17 {Rlat}
RV_10_18 n_10_18 n_11_18 {Rlat}
RV_10_19 n_10_19 n_11_19 {Rlat}
RV_10_20 n_10_20 n_11_20 {Rlat}
RV_11_1 n_11_1 n_12_1 {Rlat}
RV_11_2 n_11_2 n_12_2 {Rlat}
RV_11_3 n_11_3 n_12_3 {Rlat}
RV_11_4 n_11_4 n_12_4 {Rlat}
RV_11_5 n_11_5 n_12_5 {Rlat}
RV_11_6 n_11_6 n_12_6 {Rlat}
RV_11_7 n_11_7 n_12_7 {Rlat}
RV_11_8 n_11_8 n_12_8 {Rlat}
RV_11_9 n_11_9 n_12_9 {Rlat}
RV_11_10 n_11_10 n_12_10 {Rlat}
RV_11_11 n_11_11 n_12_11 {Rlat}
RV_11_12 n_11_12 n_12_12 {Rlat}
RV_11_13 n_11_13 n_12_13 {Rlat}
RV_11_14 n_11_14 n_12_14 {Rlat}
RV_11_15 n_11_15 n_12_15 {Rlat}
RV_11_16 n_11_16 n_12_16 {Rlat}
RV_11_17 n_11_17 n_12_17 {Rlat}
RV_11_18 n_11_18 n_12_18 {Rlat}
RV_11_19 n_11_19 n_12_19 {Rlat}
RV_11_20 n_11_20 n_12_20 {Rlat}
RV_12_1 n_12_1 n_13_1 {Rlat}
RV_12_2 n_12_2 n_13_2 {Rlat}
RV_12_3 n_12_3 n_13_3 {Rlat}
RV_12_4 n_12_4 n_13_4 {Rlat}
RV_12_5 n_12_5 n_13_5 {Rlat}
RV_12_6 n_12_6 n_13_6 {Rlat}
RV_12_7 n_12_7 n_13_7 {Rlat}
RV_12_8 n_12_8 n_13_8 {Rlat}
RV_12_9 n_12_9 n_13_9 {Rlat}
RV_12_10 n_12_10 n_13_10 {Rlat}
RV_12_11 n_12_11 n_13_11 {Rlat}
RV_12_12 n_12_12 n_13_12 {Rlat}
RV_12_13 n_12_13 n_13_13 {Rlat}
RV_12_14 n_12_14 n_13_14 {Rlat}
RV_12_15 n_12_15 n_13_15 {Rlat}
RV_12_16 n_12_16 n_13_16 {Rlat}
RV_12_17 n_12_17 n_13_17 {Rlat}
RV_12_18 n_12_18 n_13_18 {Rlat}
RV_12_19 n_12_19 n_13_19 {Rlat}
RV_12_20 n_12_20 n_13_20 {Rlat}
RV_13_1 n_13_1 n_14_1 {Rlat}
RV_13_2 n_13_2 n_14_2 {Rlat}
RV_13_3 n_13_3 n_14_3 {Rlat}
RV_13_4 n_13_4 n_14_4 {Rlat}
RV_13_5 n_13_5 n_14_5 {Rlat}
RV_13_6 n_13_6 n_14_6 {Rlat}
RV_13_7 n_13_7 n_14_7 {Rlat}
RV_13_8 n_13_8 n_14_8 {Rlat}
RV_13_9 n_13_9 n_14_9 {Rlat}
RV_13_10 n_13_10 n_14_10 {Rlat}
RV_13_11 n_13_11 n_14_11 {Rlat}
RV_13_12 n_13_12 n_14_12 {Rlat}
RV_13_13 n_13_13 n_14_13 {Rlat}
RV_13_14 n_13_14 n_14_14 {Rlat}
RV_13_15 n_13_15 n_14_15 {Rlat}
RV_13_16 n_13_16 n_14_16 {Rlat}
RV_13_17 n_13_17 n_14_17 {Rlat}
RV_13_18 n_13_18 n_14_18 {Rlat}
RV_13_19 n_13_19 n_14_19 {Rlat}
RV_13_20 n_13_20 n_14_20 {Rlat}
RV_14_1 n_14_1 n_15_1 {Rlat}
RV_14_2 n_14_2 n_15_2 {Rlat}
RV_14_3 n_14_3 n_15_3 {Rlat}
RV_14_4 n_14_4 n_15_4 {Rlat}
RV_14_5 n_14_5 n_15_5 {Rlat}
RV_14_6 n_14_6 n_15_6 {Rlat}
RV_14_7 n_14_7 n_15_7 {Rlat}
RV_14_8 n_14_8 n_15_8 {Rlat}
RV_14_9 n_14_9 n_15_9 {Rlat}
RV_14_10 n_14_10 n_15_10 {Rlat}
RV_14_11 n_14_11 n_15_11 {Rlat}
RV_14_12 n_14_12 n_15_12 {Rlat}
RV_14_13 n_14_13 n_15_13 {Rlat}
RV_14_14 n_14_14 n_15_14 {Rlat}
RV_14_15 n_14_15 n_15_15 {Rlat}
RV_14_16 n_14_16 n_15_16 {Rlat}
RV_14_17 n_14_17 n_15_17 {Rlat}
RV_14_18 n_14_18 n_15_18 {Rlat}
RV_14_19 n_14_19 n_15_19 {Rlat}
RV_14_20 n_14_20 n_15_20 {Rlat}
RV_15_1 n_15_1 n_16_1 {Rlat}
RV_15_2 n_15_2 n_16_2 {Rlat}
RV_15_3 n_15_3 n_16_3 {Rlat}
RV_15_4 n_15_4 n_16_4 {Rlat}
RV_15_5 n_15_5 n_16_5 {Rlat}
RV_15_6 n_15_6 n_16_6 {Rlat}
RV_15_7 n_15_7 n_16_7 {Rlat}
RV_15_8 n_15_8 n_16_8 {Rlat}
RV_15_9 n_15_9 n_16_9 {Rlat}
RV_15_10 n_15_10 n_16_10 {Rlat}
RV_15_11 n_15_11 n_16_11 {Rlat}
RV_15_12 n_15_12 n_16_12 {Rlat}
RV_15_13 n_15_13 n_16_13 {Rlat}
RV_15_14 n_15_14 n_16_14 {Rlat}
RV_15_15 n_15_15 n_16_15 {Rlat}
RV_15_16 n_15_16 n_16_16 {Rlat}
RV_15_17 n_15_17 n_16_17 {Rlat}
RV_15_18 n_15_18 n_16_18 {Rlat}
RV_15_19 n_15_19 n_16_19 {Rlat}
RV_15_20 n_15_20 n_16_20 {Rlat}
RV_16_1 n_16_1 n_17_1 {Rlat}
RV_16_2 n_16_2 n_17_2 {Rlat}
RV_16_3 n_16_3 n_17_3 {Rlat}
RV_16_4 n_16_4 n_17_4 {Rlat}
RV_16_5 n_16_5 n_17_5 {Rlat}
RV_16_6 n_16_6 n_17_6 {Rlat}
RV_16_7 n_16_7 n_17_7 {Rlat}
RV_16_8 n_16_8 n_17_8 {Rlat}
RV_16_9 n_16_9 n_17_9 {Rlat}
RV_16_10 n_16_10 n_17_10 {Rlat}
RV_16_11 n_16_11 n_17_11 {Rlat}
RV_16_12 n_16_12 n_17_12 {Rlat}
RV_16_13 n_16_13 n_17_13 {Rlat}
RV_16_14 n_16_14 n_17_14 {Rlat}
RV_16_15 n_16_15 n_17_15 {Rlat}
RV_16_16 n_16_16 n_17_16 {Rlat}
RV_16_17 n_16_17 n_17_17 {Rlat}
RV_16_18 n_16_18 n_17_18 {Rlat}
RV_16_19 n_16_19 n_17_19 {Rlat}
RV_16_20 n_16_20 n_17_20 {Rlat}
RV_17_1 n_17_1 n_18_1 {Rlat}
RV_17_2 n_17_2 n_18_2 {Rlat}
RV_17_3 n_17_3 n_18_3 {Rlat}
RV_17_4 n_17_4 n_18_4 {Rlat}
RV_17_5 n_17_5 n_18_5 {Rlat}
RV_17_6 n_17_6 n_18_6 {Rlat}
RV_17_7 n_17_7 n_18_7 {Rlat}
RV_17_8 n_17_8 n_18_8 {Rlat}
RV_17_9 n_17_9 n_18_9 {Rlat}
RV_17_10 n_17_10 n_18_10 {Rlat}
RV_17_11 n_17_11 n_18_11 {Rlat}
RV_17_12 n_17_12 n_18_12 {Rlat}
RV_17_13 n_17_13 n_18_13 {Rlat}
RV_17_14 n_17_14 n_18_14 {Rlat}
RV_17_15 n_17_15 n_18_15 {Rlat}
RV_17_16 n_17_16 n_18_16 {Rlat}
RV_17_17 n_17_17 n_18_17 {Rlat}
RV_17_18 n_17_18 n_18_18 {Rlat}
RV_17_19 n_17_19 n_18_19 {Rlat}
RV_17_20 n_17_20 n_18_20 {Rlat}
RV_18_1 n_18_1 n_19_1 {Rlat}
RV_18_2 n_18_2 n_19_2 {Rlat}
RV_18_3 n_18_3 n_19_3 {Rlat}
RV_18_4 n_18_4 n_19_4 {Rlat}
RV_18_5 n_18_5 n_19_5 {Rlat}
RV_18_6 n_18_6 n_19_6 {Rlat}
RV_18_7 n_18_7 n_19_7 {Rlat}
RV_18_8 n_18_8 n_19_8 {Rlat}
RV_18_9 n_18_9 n_19_9 {Rlat}
RV_18_10 n_18_10 n_19_10 {Rlat}
RV_18_11 n_18_11 n_19_11 {Rlat}
RV_18_12 n_18_12 n_19_12 {Rlat}
RV_18_13 n_18_13 n_19_13 {Rlat}
RV_18_14 n_18_14 n_19_14 {Rlat}
RV_18_15 n_18_15 n_19_15 {Rlat}
RV_18_16 n_18_16 n_19_16 {Rlat}
RV_18_17 n_18_17 n_19_17 {Rlat}
RV_18_18 n_18_18 n_19_18 {Rlat}
RV_18_19 n_18_19 n_19_19 {Rlat}
RV_18_20 n_18_20 n_19_20 {Rlat}
RV_19_1 n_19_1 n_20_1 {Rlat}
RV_19_2 n_19_2 n_20_2 {Rlat}
RV_19_3 n_19_3 n_20_3 {Rlat}
RV_19_4 n_19_4 n_20_4 {Rlat}
RV_19_5 n_19_5 n_20_5 {Rlat}
RV_19_6 n_19_6 n_20_6 {Rlat}
RV_19_7 n_19_7 n_20_7 {Rlat}
RV_19_8 n_19_8 n_20_8 {Rlat}
RV_19_9 n_19_9 n_20_9 {Rlat}
RV_19_10 n_19_10 n_20_10 {Rlat}
RV_19_11 n_19_11 n_20_11 {Rlat}
RV_19_12 n_19_12 n_20_12 {Rlat}
RV_19_13 n_19_13 n_20_13 {Rlat}
RV_19_14 n_19_14 n_20_14 {Rlat}
RV_19_15 n_19_15 n_20_15 {Rlat}
RV_19_16 n_19_16 n_20_16 {Rlat}
RV_19_17 n_19_17 n_20_17 {Rlat}
RV_19_18 n_19_18 n_20_18 {Rlat}
RV_19_19 n_19_19 n_20_19 {Rlat}
RV_19_20 n_19_20 n_20_20 {Rlat}

*=========== Vias (Upper <-> Lower) ===========
RVia_1_1 n_1_1_h n_1_1 {Rvia_cell}
RVia_1_2 n_1_2_h n_1_2 {Rvia_cell}
RVia_1_3 n_1_3_h n_1_3 {Rvia_cell}
RVia_1_4 n_1_4_h n_1_4 {Rvia_cell}
RVia_1_5 n_1_5_h n_1_5 {Rvia_cell}
RVia_1_6 n_1_6_h n_1_6 {Rvia_cell}
RVia_1_7 n_1_7_h n_1_7 {Rvia_cell}
RVia_1_8 n_1_8_h n_1_8 {Rvia_cell}
RVia_1_9 n_1_9_h n_1_9 {Rvia_cell}
RVia_1_10 n_1_10_h n_1_10 {Rvia_cell}
RVia_1_11 n_1_11_h n_1_11 {Rvia_cell}
RVia_1_12 n_1_12_h n_1_12 {Rvia_cell}
RVia_1_13 n_1_13_h n_1_13 {Rvia_cell}
RVia_1_14 n_1_14_h n_1_14 {Rvia_cell}
RVia_1_15 n_1_15_h n_1_15 {Rvia_cell}
RVia_1_16 n_1_16_h n_1_16 {Rvia_cell}
RVia_1_17 n_1_17_h n_1_17 {Rvia_cell}
RVia_1_18 n_1_18_h n_1_18 {Rvia_cell}
RVia_1_19 n_1_19_h n_1_19 {Rvia_cell}
RVia_1_20 n_1_20_h n_1_20 {Rvia_cell}
RVia_2_1 n_2_1_h n_2_1 {Rvia_cell}
RVia_2_2 n_2_2_h n_2_2 {Rvia_cell}
RVia_2_3 n_2_3_h n_2_3 {Rvia_cell}
RVia_2_4 n_2_4_h n_2_4 {Rvia_cell}
RVia_2_5 n_2_5_h n_2_5 {Rvia_cell}
RVia_2_6 n_2_6_h n_2_6 {Rvia_cell}
RVia_2_7 n_2_7_h n_2_7 {Rvia_cell}
RVia_2_8 n_2_8_h n_2_8 {Rvia_cell}
RVia_2_9 n_2_9_h n_2_9 {Rvia_cell}
RVia_2_10 n_2_10_h n_2_10 {Rvia_cell}
RVia_2_11 n_2_11_h n_2_11 {Rvia_cell}
RVia_2_12 n_2_12_h n_2_12 {Rvia_cell}
RVia_2_13 n_2_13_h n_2_13 {Rvia_cell}
RVia_2_14 n_2_14_h n_2_14 {Rvia_cell}
RVia_2_15 n_2_15_h n_2_15 {Rvia_cell}
RVia_2_16 n_2_16_h n_2_16 {Rvia_cell}
RVia_2_17 n_2_17_h n_2_17 {Rvia_cell}
RVia_2_18 n_2_18_h n_2_18 {Rvia_cell}
RVia_2_19 n_2_19_h n_2_19 {Rvia_cell}
RVia_2_20 n_2_20_h n_2_20 {Rvia_cell}
RVia_3_1 n_3_1_h n_3_1 {Rvia_cell}
RVia_3_2 n_3_2_h n_3_2 {Rvia_cell}
RVia_3_3 n_3_3_h n_3_3 {Rvia_cell}
RVia_3_4 n_3_4_h n_3_4 {Rvia_cell}
RVia_3_5 n_3_5_h n_3_5 {Rvia_cell}
RVia_3_6 n_3_6_h n_3_6 {Rvia_cell}
RVia_3_7 n_3_7_h n_3_7 {Rvia_cell}
RVia_3_8 n_3_8_h n_3_8 {Rvia_cell}
RVia_3_9 n_3_9_h n_3_9 {Rvia_cell}
RVia_3_10 n_3_10_h n_3_10 {Rvia_cell}
RVia_3_11 n_3_11_h n_3_11 {Rvia_cell}
RVia_3_12 n_3_12_h n_3_12 {Rvia_cell}
RVia_3_13 n_3_13_h n_3_13 {Rvia_cell}
RVia_3_14 n_3_14_h n_3_14 {Rvia_cell}
RVia_3_15 n_3_15_h n_3_15 {Rvia_cell}
RVia_3_16 n_3_16_h n_3_16 {Rvia_cell}
RVia_3_17 n_3_17_h n_3_17 {Rvia_cell}
RVia_3_18 n_3_18_h n_3_18 {Rvia_cell}
RVia_3_19 n_3_19_h n_3_19 {Rvia_cell}
RVia_3_20 n_3_20_h n_3_20 {Rvia_cell}
RVia_4_1 n_4_1_h n_4_1 {Rvia_cell}
RVia_4_2 n_4_2_h n_4_2 {Rvia_cell}
RVia_4_3 n_4_3_h n_4_3 {Rvia_cell}
RVia_4_4 n_4_4_h n_4_4 {Rvia_cell}
RVia_4_5 n_4_5_h n_4_5 {Rvia_cell}
RVia_4_6 n_4_6_h n_4_6 {Rvia_cell}
RVia_4_7 n_4_7_h n_4_7 {Rvia_cell}
RVia_4_8 n_4_8_h n_4_8 {Rvia_cell}
RVia_4_9 n_4_9_h n_4_9 {Rvia_cell}
RVia_4_10 n_4_10_h n_4_10 {Rvia_cell}
RVia_4_11 n_4_11_h n_4_11 {Rvia_cell}
RVia_4_12 n_4_12_h n_4_12 {Rvia_cell}
RVia_4_13 n_4_13_h n_4_13 {Rvia_cell}
RVia_4_14 n_4_14_h n_4_14 {Rvia_cell}
RVia_4_15 n_4_15_h n_4_15 {Rvia_cell}
RVia_4_16 n_4_16_h n_4_16 {Rvia_cell}
RVia_4_17 n_4_17_h n_4_17 {Rvia_cell}
RVia_4_18 n_4_18_h n_4_18 {Rvia_cell}
RVia_4_19 n_4_19_h n_4_19 {Rvia_cell}
RVia_4_20 n_4_20_h n_4_20 {Rvia_cell}
RVia_5_1 n_5_1_h n_5_1 {Rvia_cell}
RVia_5_2 n_5_2_h n_5_2 {Rvia_cell}
RVia_5_3 n_5_3_h n_5_3 {Rvia_cell}
RVia_5_4 n_5_4_h n_5_4 {Rvia_cell}
RVia_5_5 n_5_5_h n_5_5 {Rvia_cell}
RVia_5_6 n_5_6_h n_5_6 {Rvia_cell}
RVia_5_7 n_5_7_h n_5_7 {Rvia_cell}
RVia_5_8 n_5_8_h n_5_8 {Rvia_cell}
RVia_5_9 n_5_9_h n_5_9 {Rvia_cell}
RVia_5_10 n_5_10_h n_5_10 {Rvia_cell}
RVia_5_11 n_5_11_h n_5_11 {Rvia_cell}
RVia_5_12 n_5_12_h n_5_12 {Rvia_cell}
RVia_5_13 n_5_13_h n_5_13 {Rvia_cell}
RVia_5_14 n_5_14_h n_5_14 {Rvia_cell}
RVia_5_15 n_5_15_h n_5_15 {Rvia_cell}
RVia_5_16 n_5_16_h n_5_16 {Rvia_cell}
RVia_5_17 n_5_17_h n_5_17 {Rvia_cell}
RVia_5_18 n_5_18_h n_5_18 {Rvia_cell}
RVia_5_19 n_5_19_h n_5_19 {Rvia_cell}
RVia_5_20 n_5_20_h n_5_20 {Rvia_cell}
RVia_6_1 n_6_1_h n_6_1 {Rvia_cell}
RVia_6_2 n_6_2_h n_6_2 {Rvia_cell}
RVia_6_3 n_6_3_h n_6_3 {Rvia_cell}
RVia_6_4 n_6_4_h n_6_4 {Rvia_cell}
RVia_6_5 n_6_5_h n_6_5 {Rvia_cell}
RVia_6_6 n_6_6_h n_6_6 {Rvia_cell}
RVia_6_7 n_6_7_h n_6_7 {Rvia_cell}
RVia_6_8 n_6_8_h n_6_8 {Rvia_cell}
RVia_6_9 n_6_9_h n_6_9 {Rvia_cell}
RVia_6_10 n_6_10_h n_6_10 {Rvia_cell}
RVia_6_11 n_6_11_h n_6_11 {Rvia_cell}
RVia_6_12 n_6_12_h n_6_12 {Rvia_cell}
RVia_6_13 n_6_13_h n_6_13 {Rvia_cell}
RVia_6_14 n_6_14_h n_6_14 {Rvia_cell}
RVia_6_15 n_6_15_h n_6_15 {Rvia_cell}
RVia_6_16 n_6_16_h n_6_16 {Rvia_cell}
RVia_6_17 n_6_17_h n_6_17 {Rvia_cell}
RVia_6_18 n_6_18_h n_6_18 {Rvia_cell}
RVia_6_19 n_6_19_h n_6_19 {Rvia_cell}
RVia_6_20 n_6_20_h n_6_20 {Rvia_cell}
RVia_7_1 n_7_1_h n_7_1 {Rvia_cell}
RVia_7_2 n_7_2_h n_7_2 {Rvia_cell}
RVia_7_3 n_7_3_h n_7_3 {Rvia_cell}
RVia_7_4 n_7_4_h n_7_4 {Rvia_cell}
RVia_7_5 n_7_5_h n_7_5 {Rvia_cell}
RVia_7_6 n_7_6_h n_7_6 {Rvia_cell}
RVia_7_7 n_7_7_h n_7_7 {Rvia_cell}
RVia_7_8 n_7_8_h n_7_8 {Rvia_cell}
RVia_7_9 n_7_9_h n_7_9 {Rvia_cell}
RVia_7_10 n_7_10_h n_7_10 {Rvia_cell}
RVia_7_11 n_7_11_h n_7_11 {Rvia_cell}
RVia_7_12 n_7_12_h n_7_12 {Rvia_cell}
RVia_7_13 n_7_13_h n_7_13 {Rvia_cell}
RVia_7_14 n_7_14_h n_7_14 {Rvia_cell}
RVia_7_15 n_7_15_h n_7_15 {Rvia_cell}
RVia_7_16 n_7_16_h n_7_16 {Rvia_cell}
RVia_7_17 n_7_17_h n_7_17 {Rvia_cell}
RVia_7_18 n_7_18_h n_7_18 {Rvia_cell}
RVia_7_19 n_7_19_h n_7_19 {Rvia_cell}
RVia_7_20 n_7_20_h n_7_20 {Rvia_cell}
RVia_8_1 n_8_1_h n_8_1 {Rvia_cell}
RVia_8_2 n_8_2_h n_8_2 {Rvia_cell}
RVia_8_3 n_8_3_h n_8_3 {Rvia_cell}
RVia_8_4 n_8_4_h n_8_4 {Rvia_cell}
RVia_8_5 n_8_5_h n_8_5 {Rvia_cell}
RVia_8_6 n_8_6_h n_8_6 {Rvia_cell}
RVia_8_7 n_8_7_h n_8_7 {Rvia_cell}
RVia_8_8 n_8_8_h n_8_8 {Rvia_cell}
RVia_8_9 n_8_9_h n_8_9 {Rvia_cell}
RVia_8_10 n_8_10_h n_8_10 {Rvia_cell}
RVia_8_11 n_8_11_h n_8_11 {Rvia_cell}
RVia_8_12 n_8_12_h n_8_12 {Rvia_cell}
RVia_8_13 n_8_13_h n_8_13 {Rvia_cell}
RVia_8_14 n_8_14_h n_8_14 {Rvia_cell}
RVia_8_15 n_8_15_h n_8_15 {Rvia_cell}
RVia_8_16 n_8_16_h n_8_16 {Rvia_cell}
RVia_8_17 n_8_17_h n_8_17 {Rvia_cell}
RVia_8_18 n_8_18_h n_8_18 {Rvia_cell}
RVia_8_19 n_8_19_h n_8_19 {Rvia_cell}
RVia_8_20 n_8_20_h n_8_20 {Rvia_cell}
RVia_9_1 n_9_1_h n_9_1 {Rvia_cell}
RVia_9_2 n_9_2_h n_9_2 {Rvia_cell}
RVia_9_3 n_9_3_h n_9_3 {Rvia_cell}
RVia_9_4 n_9_4_h n_9_4 {Rvia_cell}
RVia_9_5 n_9_5_h n_9_5 {Rvia_cell}
RVia_9_6 n_9_6_h n_9_6 {Rvia_cell}
RVia_9_7 n_9_7_h n_9_7 {Rvia_cell}
RVia_9_8 n_9_8_h n_9_8 {Rvia_cell}
RVia_9_9 n_9_9_h n_9_9 {Rvia_cell}
RVia_9_10 n_9_10_h n_9_10 {Rvia_cell}
RVia_9_11 n_9_11_h n_9_11 {Rvia_cell}
RVia_9_12 n_9_12_h n_9_12 {Rvia_cell}
RVia_9_13 n_9_13_h n_9_13 {Rvia_cell}
RVia_9_14 n_9_14_h n_9_14 {Rvia_cell}
RVia_9_15 n_9_15_h n_9_15 {Rvia_cell}
RVia_9_16 n_9_16_h n_9_16 {Rvia_cell}
RVia_9_17 n_9_17_h n_9_17 {Rvia_cell}
RVia_9_18 n_9_18_h n_9_18 {Rvia_cell}
RVia_9_19 n_9_19_h n_9_19 {Rvia_cell}
RVia_9_20 n_9_20_h n_9_20 {Rvia_cell}
RVia_10_1 n_10_1_h n_10_1 {Rvia_cell}
RVia_10_2 n_10_2_h n_10_2 {Rvia_cell}
RVia_10_3 n_10_3_h n_10_3 {Rvia_cell}
RVia_10_4 n_10_4_h n_10_4 {Rvia_cell}
RVia_10_5 n_10_5_h n_10_5 {Rvia_cell}
RVia_10_6 n_10_6_h n_10_6 {Rvia_cell}
RVia_10_7 n_10_7_h n_10_7 {Rvia_cell}
RVia_10_8 n_10_8_h n_10_8 {Rvia_cell}
RVia_10_9 n_10_9_h n_10_9 {Rvia_cell}
RVia_10_10 n_10_10_h n_10_10 {Rvia_cell}
RVia_10_11 n_10_11_h n_10_11 {Rvia_cell}
RVia_10_12 n_10_12_h n_10_12 {Rvia_cell}
RVia_10_13 n_10_13_h n_10_13 {Rvia_cell}
RVia_10_14 n_10_14_h n_10_14 {Rvia_cell}
RVia_10_15 n_10_15_h n_10_15 {Rvia_cell}
RVia_10_16 n_10_16_h n_10_16 {Rvia_cell}
RVia_10_17 n_10_17_h n_10_17 {Rvia_cell}
RVia_10_18 n_10_18_h n_10_18 {Rvia_cell}
RVia_10_19 n_10_19_h n_10_19 {Rvia_cell}
RVia_10_20 n_10_20_h n_10_20 {Rvia_cell}
RVia_11_1 n_11_1_h n_11_1 {Rvia_cell}
RVia_11_2 n_11_2_h n_11_2 {Rvia_cell}
RVia_11_3 n_11_3_h n_11_3 {Rvia_cell}
RVia_11_4 n_11_4_h n_11_4 {Rvia_cell}
RVia_11_5 n_11_5_h n_11_5 {Rvia_cell}
RVia_11_6 n_11_6_h n_11_6 {Rvia_cell}
RVia_11_7 n_11_7_h n_11_7 {Rvia_cell}
RVia_11_8 n_11_8_h n_11_8 {Rvia_cell}
RVia_11_9 n_11_9_h n_11_9 {Rvia_cell}
RVia_11_10 n_11_10_h n_11_10 {Rvia_cell}
RVia_11_11 n_11_11_h n_11_11 {Rvia_cell}
RVia_11_12 n_11_12_h n_11_12 {Rvia_cell}
RVia_11_13 n_11_13_h n_11_13 {Rvia_cell}
RVia_11_14 n_11_14_h n_11_14 {Rvia_cell}
RVia_11_15 n_11_15_h n_11_15 {Rvia_cell}
RVia_11_16 n_11_16_h n_11_16 {Rvia_cell}
RVia_11_17 n_11_17_h n_11_17 {Rvia_cell}
RVia_11_18 n_11_18_h n_11_18 {Rvia_cell}
RVia_11_19 n_11_19_h n_11_19 {Rvia_cell}
RVia_11_20 n_11_20_h n_11_20 {Rvia_cell}
RVia_12_1 n_12_1_h n_12_1 {Rvia_cell}
RVia_12_2 n_12_2_h n_12_2 {Rvia_cell}
RVia_12_3 n_12_3_h n_12_3 {Rvia_cell}
RVia_12_4 n_12_4_h n_12_4 {Rvia_cell}
RVia_12_5 n_12_5_h n_12_5 {Rvia_cell}
RVia_12_6 n_12_6_h n_12_6 {Rvia_cell}
RVia_12_7 n_12_7_h n_12_7 {Rvia_cell}
RVia_12_8 n_12_8_h n_12_8 {Rvia_cell}
RVia_12_9 n_12_9_h n_12_9 {Rvia_cell}
RVia_12_10 n_12_10_h n_12_10 {Rvia_cell}
RVia_12_11 n_12_11_h n_12_11 {Rvia_cell}
RVia_12_12 n_12_12_h n_12_12 {Rvia_cell}
RVia_12_13 n_12_13_h n_12_13 {Rvia_cell}
RVia_12_14 n_12_14_h n_12_14 {Rvia_cell}
RVia_12_15 n_12_15_h n_12_15 {Rvia_cell}
RVia_12_16 n_12_16_h n_12_16 {Rvia_cell}
RVia_12_17 n_12_17_h n_12_17 {Rvia_cell}
RVia_12_18 n_12_18_h n_12_18 {Rvia_cell}
RVia_12_19 n_12_19_h n_12_19 {Rvia_cell}
RVia_12_20 n_12_20_h n_12_20 {Rvia_cell}
RVia_13_1 n_13_1_h n_13_1 {Rvia_cell}
RVia_13_2 n_13_2_h n_13_2 {Rvia_cell}
RVia_13_3 n_13_3_h n_13_3 {Rvia_cell}
RVia_13_4 n_13_4_h n_13_4 {Rvia_cell}
RVia_13_5 n_13_5_h n_13_5 {Rvia_cell}
RVia_13_6 n_13_6_h n_13_6 {Rvia_cell}
RVia_13_7 n_13_7_h n_13_7 {Rvia_cell}
RVia_13_8 n_13_8_h n_13_8 {Rvia_cell}
RVia_13_9 n_13_9_h n_13_9 {Rvia_cell}
RVia_13_10 n_13_10_h n_13_10 {Rvia_cell}
RVia_13_11 n_13_11_h n_13_11 {Rvia_cell}
RVia_13_12 n_13_12_h n_13_12 {Rvia_cell}
RVia_13_13 n_13_13_h n_13_13 {Rvia_cell}
RVia_13_14 n_13_14_h n_13_14 {Rvia_cell}
RVia_13_15 n_13_15_h n_13_15 {Rvia_cell}
RVia_13_16 n_13_16_h n_13_16 {Rvia_cell}
RVia_13_17 n_13_17_h n_13_17 {Rvia_cell}
RVia_13_18 n_13_18_h n_13_18 {Rvia_cell}
RVia_13_19 n_13_19_h n_13_19 {Rvia_cell}
RVia_13_20 n_13_20_h n_13_20 {Rvia_cell}
RVia_14_1 n_14_1_h n_14_1 {Rvia_cell}
RVia_14_2 n_14_2_h n_14_2 {Rvia_cell}
RVia_14_3 n_14_3_h n_14_3 {Rvia_cell}
RVia_14_4 n_14_4_h n_14_4 {Rvia_cell}
RVia_14_5 n_14_5_h n_14_5 {Rvia_cell}
RVia_14_6 n_14_6_h n_14_6 {Rvia_cell}
RVia_14_7 n_14_7_h n_14_7 {Rvia_cell}
RVia_14_8 n_14_8_h n_14_8 {Rvia_cell}
RVia_14_9 n_14_9_h n_14_9 {Rvia_cell}
RVia_14_10 n_14_10_h n_14_10 {Rvia_cell}
RVia_14_11 n_14_11_h n_14_11 {Rvia_cell}
RVia_14_12 n_14_12_h n_14_12 {Rvia_cell}
RVia_14_13 n_14_13_h n_14_13 {Rvia_cell}
RVia_14_14 n_14_14_h n_14_14 {Rvia_cell}
RVia_14_15 n_14_15_h n_14_15 {Rvia_cell}
RVia_14_16 n_14_16_h n_14_16 {Rvia_cell}
RVia_14_17 n_14_17_h n_14_17 {Rvia_cell}
RVia_14_18 n_14_18_h n_14_18 {Rvia_cell}
RVia_14_19 n_14_19_h n_14_19 {Rvia_cell}
RVia_14_20 n_14_20_h n_14_20 {Rvia_cell}
RVia_15_1 n_15_1_h n_15_1 {Rvia_cell}
RVia_15_2 n_15_2_h n_15_2 {Rvia_cell}
RVia_15_3 n_15_3_h n_15_3 {Rvia_cell}
RVia_15_4 n_15_4_h n_15_4 {Rvia_cell}
RVia_15_5 n_15_5_h n_15_5 {Rvia_cell}
RVia_15_6 n_15_6_h n_15_6 {Rvia_cell}
RVia_15_7 n_15_7_h n_15_7 {Rvia_cell}
RVia_15_8 n_15_8_h n_15_8 {Rvia_cell}
RVia_15_9 n_15_9_h n_15_9 {Rvia_cell}
RVia_15_10 n_15_10_h n_15_10 {Rvia_cell}
RVia_15_11 n_15_11_h n_15_11 {Rvia_cell}
RVia_15_12 n_15_12_h n_15_12 {Rvia_cell}
RVia_15_13 n_15_13_h n_15_13 {Rvia_cell}
RVia_15_14 n_15_14_h n_15_14 {Rvia_cell}
RVia_15_15 n_15_15_h n_15_15 {Rvia_cell}
RVia_15_16 n_15_16_h n_15_16 {Rvia_cell}
RVia_15_17 n_15_17_h n_15_17 {Rvia_cell}
RVia_15_18 n_15_18_h n_15_18 {Rvia_cell}
RVia_15_19 n_15_19_h n_15_19 {Rvia_cell}
RVia_15_20 n_15_20_h n_15_20 {Rvia_cell}
RVia_16_1 n_16_1_h n_16_1 {Rvia_cell}
RVia_16_2 n_16_2_h n_16_2 {Rvia_cell}
RVia_16_3 n_16_3_h n_16_3 {Rvia_cell}
RVia_16_4 n_16_4_h n_16_4 {Rvia_cell}
RVia_16_5 n_16_5_h n_16_5 {Rvia_cell}
RVia_16_6 n_16_6_h n_16_6 {Rvia_cell}
RVia_16_7 n_16_7_h n_16_7 {Rvia_cell}
RVia_16_8 n_16_8_h n_16_8 {Rvia_cell}
RVia_16_9 n_16_9_h n_16_9 {Rvia_cell}
RVia_16_10 n_16_10_h n_16_10 {Rvia_cell}
RVia_16_11 n_16_11_h n_16_11 {Rvia_cell}
RVia_16_12 n_16_12_h n_16_12 {Rvia_cell}
RVia_16_13 n_16_13_h n_16_13 {Rvia_cell}
RVia_16_14 n_16_14_h n_16_14 {Rvia_cell}
RVia_16_15 n_16_15_h n_16_15 {Rvia_cell}
RVia_16_16 n_16_16_h n_16_16 {Rvia_cell}
RVia_16_17 n_16_17_h n_16_17 {Rvia_cell}
RVia_16_18 n_16_18_h n_16_18 {Rvia_cell}
RVia_16_19 n_16_19_h n_16_19 {Rvia_cell}
RVia_16_20 n_16_20_h n_16_20 {Rvia_cell}
RVia_17_1 n_17_1_h n_17_1 {Rvia_cell}
RVia_17_2 n_17_2_h n_17_2 {Rvia_cell}
RVia_17_3 n_17_3_h n_17_3 {Rvia_cell}
RVia_17_4 n_17_4_h n_17_4 {Rvia_cell}
RVia_17_5 n_17_5_h n_17_5 {Rvia_cell}
RVia_17_6 n_17_6_h n_17_6 {Rvia_cell}
RVia_17_7 n_17_7_h n_17_7 {Rvia_cell}
RVia_17_8 n_17_8_h n_17_8 {Rvia_cell}
RVia_17_9 n_17_9_h n_17_9 {Rvia_cell}
RVia_17_10 n_17_10_h n_17_10 {Rvia_cell}
RVia_17_11 n_17_11_h n_17_11 {Rvia_cell}
RVia_17_12 n_17_12_h n_17_12 {Rvia_cell}
RVia_17_13 n_17_13_h n_17_13 {Rvia_cell}
RVia_17_14 n_17_14_h n_17_14 {Rvia_cell}
RVia_17_15 n_17_15_h n_17_15 {Rvia_cell}
RVia_17_16 n_17_16_h n_17_16 {Rvia_cell}
RVia_17_17 n_17_17_h n_17_17 {Rvia_cell}
RVia_17_18 n_17_18_h n_17_18 {Rvia_cell}
RVia_17_19 n_17_19_h n_17_19 {Rvia_cell}
RVia_17_20 n_17_20_h n_17_20 {Rvia_cell}
RVia_18_1 n_18_1_h n_18_1 {Rvia_cell}
RVia_18_2 n_18_2_h n_18_2 {Rvia_cell}
RVia_18_3 n_18_3_h n_18_3 {Rvia_cell}
RVia_18_4 n_18_4_h n_18_4 {Rvia_cell}
RVia_18_5 n_18_5_h n_18_5 {Rvia_cell}
RVia_18_6 n_18_6_h n_18_6 {Rvia_cell}
RVia_18_7 n_18_7_h n_18_7 {Rvia_cell}
RVia_18_8 n_18_8_h n_18_8 {Rvia_cell}
RVia_18_9 n_18_9_h n_18_9 {Rvia_cell}
RVia_18_10 n_18_10_h n_18_10 {Rvia_cell}
RVia_18_11 n_18_11_h n_18_11 {Rvia_cell}
RVia_18_12 n_18_12_h n_18_12 {Rvia_cell}
RVia_18_13 n_18_13_h n_18_13 {Rvia_cell}
RVia_18_14 n_18_14_h n_18_14 {Rvia_cell}
RVia_18_15 n_18_15_h n_18_15 {Rvia_cell}
RVia_18_16 n_18_16_h n_18_16 {Rvia_cell}
RVia_18_17 n_18_17_h n_18_17 {Rvia_cell}
RVia_18_18 n_18_18_h n_18_18 {Rvia_cell}
RVia_18_19 n_18_19_h n_18_19 {Rvia_cell}
RVia_18_20 n_18_20_h n_18_20 {Rvia_cell}
RVia_19_1 n_19_1_h n_19_1 {Rvia_cell}
RVia_19_2 n_19_2_h n_19_2 {Rvia_cell}
RVia_19_3 n_19_3_h n_19_3 {Rvia_cell}
RVia_19_4 n_19_4_h n_19_4 {Rvia_cell}
RVia_19_5 n_19_5_h n_19_5 {Rvia_cell}
RVia_19_6 n_19_6_h n_19_6 {Rvia_cell}
RVia_19_7 n_19_7_h n_19_7 {Rvia_cell}
RVia_19_8 n_19_8_h n_19_8 {Rvia_cell}
RVia_19_9 n_19_9_h n_19_9 {Rvia_cell}
RVia_19_10 n_19_10_h n_19_10 {Rvia_cell}
RVia_19_11 n_19_11_h n_19_11 {Rvia_cell}
RVia_19_12 n_19_12_h n_19_12 {Rvia_cell}
RVia_19_13 n_19_13_h n_19_13 {Rvia_cell}
RVia_19_14 n_19_14_h n_19_14 {Rvia_cell}
RVia_19_15 n_19_15_h n_19_15 {Rvia_cell}
RVia_19_16 n_19_16_h n_19_16 {Rvia_cell}
RVia_19_17 n_19_17_h n_19_17 {Rvia_cell}
RVia_19_18 n_19_18_h n_19_18 {Rvia_cell}
RVia_19_19 n_19_19_h n_19_19 {Rvia_cell}
RVia_19_20 n_19_20_h n_19_20 {Rvia_cell}
RVia_20_1 n_20_1_h n_20_1 {Rvia_cell}
RVia_20_2 n_20_2_h n_20_2 {Rvia_cell}
RVia_20_3 n_20_3_h n_20_3 {Rvia_cell}
RVia_20_4 n_20_4_h n_20_4 {Rvia_cell}
RVia_20_5 n_20_5_h n_20_5 {Rvia_cell}
RVia_20_6 n_20_6_h n_20_6 {Rvia_cell}
RVia_20_7 n_20_7_h n_20_7 {Rvia_cell}
RVia_20_8 n_20_8_h n_20_8 {Rvia_cell}
RVia_20_9 n_20_9_h n_20_9 {Rvia_cell}
RVia_20_10 n_20_10_h n_20_10 {Rvia_cell}
RVia_20_11 n_20_11_h n_20_11 {Rvia_cell}
RVia_20_12 n_20_12_h n_20_12 {Rvia_cell}
RVia_20_13 n_20_13_h n_20_13 {Rvia_cell}
RVia_20_14 n_20_14_h n_20_14 {Rvia_cell}
RVia_20_15 n_20_15_h n_20_15 {Rvia_cell}
RVia_20_16 n_20_16_h n_20_16 {Rvia_cell}
RVia_20_17 n_20_17_h n_20_17 {Rvia_cell}
RVia_20_18 n_20_18_h n_20_18 {Rvia_cell}
RVia_20_19 n_20_19_h n_20_19 {Rvia_cell}
RVia_20_20 n_20_20_h n_20_20 {Rvia_cell}

*=========== Current Source Loads ===========
Ic_1_1 n_1_1 0 {Iload/Ncells}
Ic_1_2 n_1_2 0 {Iload/Ncells}
Ic_1_3 n_1_3 0 {Iload/Ncells}
Ic_1_4 n_1_4 0 {Iload/Ncells}
Ic_1_5 n_1_5 0 {Iload/Ncells}
Ic_1_6 n_1_6 0 {Iload/Ncells}
Ic_1_7 n_1_7 0 {Iload/Ncells}
Ic_1_8 n_1_8 0 {Iload/Ncells}
Ic_1_9 n_1_9 0 {Iload/Ncells}
Ic_1_10 n_1_10 0 {Iload/Ncells}
Ic_1_11 n_1_11 0 {Iload/Ncells}
Ic_1_12 n_1_12 0 {Iload/Ncells}
Ic_1_13 n_1_13 0 {Iload/Ncells}
Ic_1_14 n_1_14 0 {Iload/Ncells}
Ic_1_15 n_1_15 0 {Iload/Ncells}
Ic_1_16 n_1_16 0 {Iload/Ncells}
Ic_1_17 n_1_17 0 {Iload/Ncells}
Ic_1_18 n_1_18 0 {Iload/Ncells}
Ic_1_19 n_1_19 0 {Iload/Ncells}
Ic_1_20 n_1_20 0 {Iload/Ncells}
Ic_2_1 n_2_1 0 {Iload/Ncells}
Ic_2_2 n_2_2 0 {Iload/Ncells}
Ic_2_3 n_2_3 0 {Iload/Ncells}
Ic_2_4 n_2_4 0 {Iload/Ncells}
Ic_2_5 n_2_5 0 {Iload/Ncells}
Ic_2_6 n_2_6 0 {Iload/Ncells}
Ic_2_7 n_2_7 0 {Iload/Ncells}
Ic_2_8 n_2_8 0 {Iload/Ncells}
Ic_2_9 n_2_9 0 {Iload/Ncells}
Ic_2_10 n_2_10 0 {Iload/Ncells}
Ic_2_11 n_2_11 0 {Iload/Ncells}
Ic_2_12 n_2_12 0 {Iload/Ncells}
Ic_2_13 n_2_13 0 {Iload/Ncells}
Ic_2_14 n_2_14 0 {Iload/Ncells}
Ic_2_15 n_2_15 0 {Iload/Ncells}
Ic_2_16 n_2_16 0 {Iload/Ncells}
Ic_2_17 n_2_17 0 {Iload/Ncells}
Ic_2_18 n_2_18 0 {Iload/Ncells}
Ic_2_19 n_2_19 0 {Iload/Ncells}
Ic_2_20 n_2_20 0 {Iload/Ncells}
Ic_3_1 n_3_1 0 {Iload/Ncells}
Ic_3_2 n_3_2 0 {Iload/Ncells}
Ic_3_3 n_3_3 0 {Iload/Ncells}
Ic_3_4 n_3_4 0 {Iload/Ncells}
Ic_3_5 n_3_5 0 {Iload/Ncells}
Ic_3_6 n_3_6 0 {Iload/Ncells}
Ic_3_7 n_3_7 0 {Iload/Ncells}
Ic_3_8 n_3_8 0 {Iload/Ncells}
Ic_3_9 n_3_9 0 {Iload/Ncells}
Ic_3_10 n_3_10 0 {Iload/Ncells}
Ic_3_11 n_3_11 0 {Iload/Ncells}
Ic_3_12 n_3_12 0 {Iload/Ncells}
Ic_3_13 n_3_13 0 {Iload/Ncells}
Ic_3_14 n_3_14 0 {Iload/Ncells}
Ic_3_15 n_3_15 0 {Iload/Ncells}
Ic_3_16 n_3_16 0 {Iload/Ncells}
Ic_3_17 n_3_17 0 {Iload/Ncells}
Ic_3_18 n_3_18 0 {Iload/Ncells}
Ic_3_19 n_3_19 0 {Iload/Ncells}
Ic_3_20 n_3_20 0 {Iload/Ncells}
Ic_4_1 n_4_1 0 {Iload/Ncells}
Ic_4_2 n_4_2 0 {Iload/Ncells}
Ic_4_3 n_4_3 0 {Iload/Ncells}
Ic_4_4 n_4_4 0 {Iload/Ncells}
Ic_4_5 n_4_5 0 {Iload/Ncells}
Ic_4_6 n_4_6 0 {Iload/Ncells}
Ic_4_7 n_4_7 0 {Iload/Ncells}
Ic_4_8 n_4_8 0 {Iload/Ncells}
Ic_4_9 n_4_9 0 {Iload/Ncells}
Ic_4_10 n_4_10 0 {Iload/Ncells}
Ic_4_11 n_4_11 0 {Iload/Ncells}
Ic_4_12 n_4_12 0 {Iload/Ncells}
Ic_4_13 n_4_13 0 {Iload/Ncells}
Ic_4_14 n_4_14 0 {Iload/Ncells}
Ic_4_15 n_4_15 0 {Iload/Ncells}
Ic_4_16 n_4_16 0 {Iload/Ncells}
Ic_4_17 n_4_17 0 {Iload/Ncells}
Ic_4_18 n_4_18 0 {Iload/Ncells}
Ic_4_19 n_4_19 0 {Iload/Ncells}
Ic_4_20 n_4_20 0 {Iload/Ncells}
Ic_5_1 n_5_1 0 {Iload/Ncells}
Ic_5_2 n_5_2 0 {Iload/Ncells}
Ic_5_3 n_5_3 0 {Iload/Ncells}
Ic_5_4 n_5_4 0 {Iload/Ncells}
Ic_5_5 n_5_5 0 {Iload/Ncells}
Ic_5_6 n_5_6 0 {Iload/Ncells}
Ic_5_7 n_5_7 0 {Iload/Ncells}
Ic_5_8 n_5_8 0 {Iload/Ncells}
Ic_5_9 n_5_9 0 {Iload/Ncells}
Ic_5_10 n_5_10 0 {Iload/Ncells}
Ic_5_11 n_5_11 0 {Iload/Ncells}
Ic_5_12 n_5_12 0 {Iload/Ncells}
Ic_5_13 n_5_13 0 {Iload/Ncells}
Ic_5_14 n_5_14 0 {Iload/Ncells}
Ic_5_15 n_5_15 0 {Iload/Ncells}
Ic_5_16 n_5_16 0 {Iload/Ncells}
Ic_5_17 n_5_17 0 {Iload/Ncells}
Ic_5_18 n_5_18 0 {Iload/Ncells}
Ic_5_19 n_5_19 0 {Iload/Ncells}
Ic_5_20 n_5_20 0 {Iload/Ncells}
Ic_6_1 n_6_1 0 {Iload/Ncells}
Ic_6_2 n_6_2 0 {Iload/Ncells}
Ic_6_3 n_6_3 0 {Iload/Ncells}
Ic_6_4 n_6_4 0 {Iload/Ncells}
Ic_6_5 n_6_5 0 {Iload/Ncells}
Ic_6_6 n_6_6 0 {Iload/Ncells}
Ic_6_7 n_6_7 0 {Iload/Ncells}
Ic_6_8 n_6_8 0 {Iload/Ncells}
Ic_6_9 n_6_9 0 {Iload/Ncells}
Ic_6_10 n_6_10 0 {Iload/Ncells}
Ic_6_11 n_6_11 0 {Iload/Ncells}
Ic_6_12 n_6_12 0 {Iload/Ncells}
Ic_6_13 n_6_13 0 {Iload/Ncells}
Ic_6_14 n_6_14 0 {Iload/Ncells}
Ic_6_15 n_6_15 0 {Iload/Ncells}
Ic_6_16 n_6_16 0 {Iload/Ncells}
Ic_6_17 n_6_17 0 {Iload/Ncells}
Ic_6_18 n_6_18 0 {Iload/Ncells}
Ic_6_19 n_6_19 0 {Iload/Ncells}
Ic_6_20 n_6_20 0 {Iload/Ncells}
Ic_7_1 n_7_1 0 {Iload/Ncells}
Ic_7_2 n_7_2 0 {Iload/Ncells}
Ic_7_3 n_7_3 0 {Iload/Ncells}
Ic_7_4 n_7_4 0 {Iload/Ncells}
Ic_7_5 n_7_5 0 {Iload/Ncells}
Ic_7_6 n_7_6 0 {Iload/Ncells}
Ic_7_7 n_7_7 0 {Iload/Ncells}
Ic_7_8 n_7_8 0 {Iload/Ncells}
Ic_7_9 n_7_9 0 {Iload/Ncells}
Ic_7_10 n_7_10 0 {Iload/Ncells}
Ic_7_11 n_7_11 0 {Iload/Ncells}
Ic_7_12 n_7_12 0 {Iload/Ncells}
Ic_7_13 n_7_13 0 {Iload/Ncells}
Ic_7_14 n_7_14 0 {Iload/Ncells}
Ic_7_15 n_7_15 0 {Iload/Ncells}
Ic_7_16 n_7_16 0 {Iload/Ncells}
Ic_7_17 n_7_17 0 {Iload/Ncells}
Ic_7_18 n_7_18 0 {Iload/Ncells}
Ic_7_19 n_7_19 0 {Iload/Ncells}
Ic_7_20 n_7_20 0 {Iload/Ncells}
Ic_8_1 n_8_1 0 {Iload/Ncells}
Ic_8_2 n_8_2 0 {Iload/Ncells}
Ic_8_3 n_8_3 0 {Iload/Ncells}
Ic_8_4 n_8_4 0 {Iload/Ncells}
Ic_8_5 n_8_5 0 {Iload/Ncells}
Ic_8_6 n_8_6 0 {Iload/Ncells}
Ic_8_7 n_8_7 0 {Iload/Ncells}
Ic_8_8 n_8_8 0 {Iload/Ncells}
Ic_8_9 n_8_9 0 {Iload/Ncells}
Ic_8_10 n_8_10 0 {Iload/Ncells}
Ic_8_11 n_8_11 0 {Iload/Ncells}
Ic_8_12 n_8_12 0 {Iload/Ncells}
Ic_8_13 n_8_13 0 {Iload/Ncells}
Ic_8_14 n_8_14 0 {Iload/Ncells}
Ic_8_15 n_8_15 0 {Iload/Ncells}
Ic_8_16 n_8_16 0 {Iload/Ncells}
Ic_8_17 n_8_17 0 {Iload/Ncells}
Ic_8_18 n_8_18 0 {Iload/Ncells}
Ic_8_19 n_8_19 0 {Iload/Ncells}
Ic_8_20 n_8_20 0 {Iload/Ncells}
Ic_9_1 n_9_1 0 {Iload/Ncells}
Ic_9_2 n_9_2 0 {Iload/Ncells}
Ic_9_3 n_9_3 0 {Iload/Ncells}
Ic_9_4 n_9_4 0 {Iload/Ncells}
Ic_9_5 n_9_5 0 {Iload/Ncells}
Ic_9_6 n_9_6 0 {Iload/Ncells}
Ic_9_7 n_9_7 0 {Iload/Ncells}
Ic_9_8 n_9_8 0 {Iload/Ncells}
Ic_9_9 n_9_9 0 {Iload/Ncells}
Ic_9_10 n_9_10 0 {Iload/Ncells}
Ic_9_11 n_9_11 0 {Iload/Ncells}
Ic_9_12 n_9_12 0 {Iload/Ncells}
Ic_9_13 n_9_13 0 {Iload/Ncells}
Ic_9_14 n_9_14 0 {Iload/Ncells}
Ic_9_15 n_9_15 0 {Iload/Ncells}
Ic_9_16 n_9_16 0 {Iload/Ncells}
Ic_9_17 n_9_17 0 {Iload/Ncells}
Ic_9_18 n_9_18 0 {Iload/Ncells}
Ic_9_19 n_9_19 0 {Iload/Ncells}
Ic_9_20 n_9_20 0 {Iload/Ncells}
Ic_10_1 n_10_1 0 {Iload/Ncells}
Ic_10_2 n_10_2 0 {Iload/Ncells}
Ic_10_3 n_10_3 0 {Iload/Ncells}
Ic_10_4 n_10_4 0 {Iload/Ncells}
Ic_10_5 n_10_5 0 {Iload/Ncells}
Ic_10_6 n_10_6 0 {Iload/Ncells}
Ic_10_7 n_10_7 0 {Iload/Ncells}
Ic_10_8 n_10_8 0 {Iload/Ncells}
Ic_10_9 n_10_9 0 {Iload/Ncells}
Ic_10_10 n_10_10 0 {Iload/Ncells}
Ic_10_11 n_10_11 0 {Iload/Ncells}
Ic_10_12 n_10_12 0 {Iload/Ncells}
Ic_10_13 n_10_13 0 {Iload/Ncells}
Ic_10_14 n_10_14 0 {Iload/Ncells}
Ic_10_15 n_10_15 0 {Iload/Ncells}
Ic_10_16 n_10_16 0 {Iload/Ncells}
Ic_10_17 n_10_17 0 {Iload/Ncells}
Ic_10_18 n_10_18 0 {Iload/Ncells}
Ic_10_19 n_10_19 0 {Iload/Ncells}
Ic_10_20 n_10_20 0 {Iload/Ncells}
Ic_11_1 n_11_1 0 {Iload/Ncells}
Ic_11_2 n_11_2 0 {Iload/Ncells}
Ic_11_3 n_11_3 0 {Iload/Ncells}
Ic_11_4 n_11_4 0 {Iload/Ncells}
Ic_11_5 n_11_5 0 {Iload/Ncells}
Ic_11_6 n_11_6 0 {Iload/Ncells}
Ic_11_7 n_11_7 0 {Iload/Ncells}
Ic_11_8 n_11_8 0 {Iload/Ncells}
Ic_11_9 n_11_9 0 {Iload/Ncells}
Ic_11_10 n_11_10 0 {Iload/Ncells}
Ic_11_11 n_11_11 0 {Iload/Ncells}
Ic_11_12 n_11_12 0 {Iload/Ncells}
Ic_11_13 n_11_13 0 {Iload/Ncells}
Ic_11_14 n_11_14 0 {Iload/Ncells}
Ic_11_15 n_11_15 0 {Iload/Ncells}
Ic_11_16 n_11_16 0 {Iload/Ncells}
Ic_11_17 n_11_17 0 {Iload/Ncells}
Ic_11_18 n_11_18 0 {Iload/Ncells}
Ic_11_19 n_11_19 0 {Iload/Ncells}
Ic_11_20 n_11_20 0 {Iload/Ncells}
Ic_12_1 n_12_1 0 {Iload/Ncells}
Ic_12_2 n_12_2 0 {Iload/Ncells}
Ic_12_3 n_12_3 0 {Iload/Ncells}
Ic_12_4 n_12_4 0 {Iload/Ncells}
Ic_12_5 n_12_5 0 {Iload/Ncells}
Ic_12_6 n_12_6 0 {Iload/Ncells}
Ic_12_7 n_12_7 0 {Iload/Ncells}
Ic_12_8 n_12_8 0 {Iload/Ncells}
Ic_12_9 n_12_9 0 {Iload/Ncells}
Ic_12_10 n_12_10 0 {Iload/Ncells}
Ic_12_11 n_12_11 0 {Iload/Ncells}
Ic_12_12 n_12_12 0 {Iload/Ncells}
Ic_12_13 n_12_13 0 {Iload/Ncells}
Ic_12_14 n_12_14 0 {Iload/Ncells}
Ic_12_15 n_12_15 0 {Iload/Ncells}
Ic_12_16 n_12_16 0 {Iload/Ncells}
Ic_12_17 n_12_17 0 {Iload/Ncells}
Ic_12_18 n_12_18 0 {Iload/Ncells}
Ic_12_19 n_12_19 0 {Iload/Ncells}
Ic_12_20 n_12_20 0 {Iload/Ncells}
Ic_13_1 n_13_1 0 {Iload/Ncells}
Ic_13_2 n_13_2 0 {Iload/Ncells}
Ic_13_3 n_13_3 0 {Iload/Ncells}
Ic_13_4 n_13_4 0 {Iload/Ncells}
Ic_13_5 n_13_5 0 {Iload/Ncells}
Ic_13_6 n_13_6 0 {Iload/Ncells}
Ic_13_7 n_13_7 0 {Iload/Ncells}
Ic_13_8 n_13_8 0 {Iload/Ncells}
Ic_13_9 n_13_9 0 {Iload/Ncells}
Ic_13_10 n_13_10 0 {Iload/Ncells}
Ic_13_11 n_13_11 0 {Iload/Ncells}
Ic_13_12 n_13_12 0 {Iload/Ncells}
Ic_13_13 n_13_13 0 {Iload/Ncells}
Ic_13_14 n_13_14 0 {Iload/Ncells}
Ic_13_15 n_13_15 0 {Iload/Ncells}
Ic_13_16 n_13_16 0 {Iload/Ncells}
Ic_13_17 n_13_17 0 {Iload/Ncells}
Ic_13_18 n_13_18 0 {Iload/Ncells}
Ic_13_19 n_13_19 0 {Iload/Ncells}
Ic_13_20 n_13_20 0 {Iload/Ncells}
Ic_14_1 n_14_1 0 {Iload/Ncells}
Ic_14_2 n_14_2 0 {Iload/Ncells}
Ic_14_3 n_14_3 0 {Iload/Ncells}
Ic_14_4 n_14_4 0 {Iload/Ncells}
Ic_14_5 n_14_5 0 {Iload/Ncells}
Ic_14_6 n_14_6 0 {Iload/Ncells}
Ic_14_7 n_14_7 0 {Iload/Ncells}
Ic_14_8 n_14_8 0 {Iload/Ncells}
Ic_14_9 n_14_9 0 {Iload/Ncells}
Ic_14_10 n_14_10 0 {Iload/Ncells}
Ic_14_11 n_14_11 0 {Iload/Ncells}
Ic_14_12 n_14_12 0 {Iload/Ncells}
Ic_14_13 n_14_13 0 {Iload/Ncells}
Ic_14_14 n_14_14 0 {Iload/Ncells}
Ic_14_15 n_14_15 0 {Iload/Ncells}
Ic_14_16 n_14_16 0 {Iload/Ncells}
Ic_14_17 n_14_17 0 {Iload/Ncells}
Ic_14_18 n_14_18 0 {Iload/Ncells}
Ic_14_19 n_14_19 0 {Iload/Ncells}
Ic_14_20 n_14_20 0 {Iload/Ncells}
Ic_15_1 n_15_1 0 {Iload/Ncells}
Ic_15_2 n_15_2 0 {Iload/Ncells}
Ic_15_3 n_15_3 0 {Iload/Ncells}
Ic_15_4 n_15_4 0 {Iload/Ncells}
Ic_15_5 n_15_5 0 {Iload/Ncells}
Ic_15_6 n_15_6 0 {Iload/Ncells}
Ic_15_7 n_15_7 0 {Iload/Ncells}
Ic_15_8 n_15_8 0 {Iload/Ncells}
Ic_15_9 n_15_9 0 {Iload/Ncells}
Ic_15_10 n_15_10 0 {Iload/Ncells}
Ic_15_11 n_15_11 0 {Iload/Ncells}
Ic_15_12 n_15_12 0 {Iload/Ncells}
Ic_15_13 n_15_13 0 {Iload/Ncells}
Ic_15_14 n_15_14 0 {Iload/Ncells}
Ic_15_15 n_15_15 0 {Iload/Ncells}
Ic_15_16 n_15_16 0 {Iload/Ncells}
Ic_15_17 n_15_17 0 {Iload/Ncells}
Ic_15_18 n_15_18 0 {Iload/Ncells}
Ic_15_19 n_15_19 0 {Iload/Ncells}
Ic_15_20 n_15_20 0 {Iload/Ncells}
Ic_16_1 n_16_1 0 {Iload/Ncells}
Ic_16_2 n_16_2 0 {Iload/Ncells}
Ic_16_3 n_16_3 0 {Iload/Ncells}
Ic_16_4 n_16_4 0 {Iload/Ncells}
Ic_16_5 n_16_5 0 {Iload/Ncells}
Ic_16_6 n_16_6 0 {Iload/Ncells}
Ic_16_7 n_16_7 0 {Iload/Ncells}
Ic_16_8 n_16_8 0 {Iload/Ncells}
Ic_16_9 n_16_9 0 {Iload/Ncells}
Ic_16_10 n_16_10 0 {Iload/Ncells}
Ic_16_11 n_16_11 0 {Iload/Ncells}
Ic_16_12 n_16_12 0 {Iload/Ncells}
Ic_16_13 n_16_13 0 {Iload/Ncells}
Ic_16_14 n_16_14 0 {Iload/Ncells}
Ic_16_15 n_16_15 0 {Iload/Ncells}
Ic_16_16 n_16_16 0 {Iload/Ncells}
Ic_16_17 n_16_17 0 {Iload/Ncells}
Ic_16_18 n_16_18 0 {Iload/Ncells}
Ic_16_19 n_16_19 0 {Iload/Ncells}
Ic_16_20 n_16_20 0 {Iload/Ncells}
Ic_17_1 n_17_1 0 {Iload/Ncells}
Ic_17_2 n_17_2 0 {Iload/Ncells}
Ic_17_3 n_17_3 0 {Iload/Ncells}
Ic_17_4 n_17_4 0 {Iload/Ncells}
Ic_17_5 n_17_5 0 {Iload/Ncells}
Ic_17_6 n_17_6 0 {Iload/Ncells}
Ic_17_7 n_17_7 0 {Iload/Ncells}
Ic_17_8 n_17_8 0 {Iload/Ncells}
Ic_17_9 n_17_9 0 {Iload/Ncells}
Ic_17_10 n_17_10 0 {Iload/Ncells}
Ic_17_11 n_17_11 0 {Iload/Ncells}
Ic_17_12 n_17_12 0 {Iload/Ncells}
Ic_17_13 n_17_13 0 {Iload/Ncells}
Ic_17_14 n_17_14 0 {Iload/Ncells}
Ic_17_15 n_17_15 0 {Iload/Ncells}
Ic_17_16 n_17_16 0 {Iload/Ncells}
Ic_17_17 n_17_17 0 {Iload/Ncells}
Ic_17_18 n_17_18 0 {Iload/Ncells}
Ic_17_19 n_17_19 0 {Iload/Ncells}
Ic_17_20 n_17_20 0 {Iload/Ncells}
Ic_18_1 n_18_1 0 {Iload/Ncells}
Ic_18_2 n_18_2 0 {Iload/Ncells}
Ic_18_3 n_18_3 0 {Iload/Ncells}
Ic_18_4 n_18_4 0 {Iload/Ncells}
Ic_18_5 n_18_5 0 {Iload/Ncells}
Ic_18_6 n_18_6 0 {Iload/Ncells}
Ic_18_7 n_18_7 0 {Iload/Ncells}
Ic_18_8 n_18_8 0 {Iload/Ncells}
Ic_18_9 n_18_9 0 {Iload/Ncells}
Ic_18_10 n_18_10 0 {Iload/Ncells}
Ic_18_11 n_18_11 0 {Iload/Ncells}
Ic_18_12 n_18_12 0 {Iload/Ncells}
Ic_18_13 n_18_13 0 {Iload/Ncells}
Ic_18_14 n_18_14 0 {Iload/Ncells}
Ic_18_15 n_18_15 0 {Iload/Ncells}
Ic_18_16 n_18_16 0 {Iload/Ncells}
Ic_18_17 n_18_17 0 {Iload/Ncells}
Ic_18_18 n_18_18 0 {Iload/Ncells}
Ic_18_19 n_18_19 0 {Iload/Ncells}
Ic_18_20 n_18_20 0 {Iload/Ncells}
Ic_19_1 n_19_1 0 {Iload/Ncells}
Ic_19_2 n_19_2 0 {Iload/Ncells}
Ic_19_3 n_19_3 0 {Iload/Ncells}
Ic_19_4 n_19_4 0 {Iload/Ncells}
Ic_19_5 n_19_5 0 {Iload/Ncells}
Ic_19_6 n_19_6 0 {Iload/Ncells}
Ic_19_7 n_19_7 0 {Iload/Ncells}
Ic_19_8 n_19_8 0 {Iload/Ncells}
Ic_19_9 n_19_9 0 {Iload/Ncells}
Ic_19_10 n_19_10 0 {Iload/Ncells}
Ic_19_11 n_19_11 0 {Iload/Ncells}
Ic_19_12 n_19_12 0 {Iload/Ncells}
Ic_19_13 n_19_13 0 {Iload/Ncells}
Ic_19_14 n_19_14 0 {Iload/Ncells}
Ic_19_15 n_19_15 0 {Iload/Ncells}
Ic_19_16 n_19_16 0 {Iload/Ncells}
Ic_19_17 n_19_17 0 {Iload/Ncells}
Ic_19_18 n_19_18 0 {Iload/Ncells}
Ic_19_19 n_19_19 0 {Iload/Ncells}
Ic_19_20 n_19_20 0 {Iload/Ncells}
Ic_20_1 n_20_1 0 {Iload/Ncells}
Ic_20_2 n_20_2 0 {Iload/Ncells}
Ic_20_3 n_20_3 0 {Iload/Ncells}
Ic_20_4 n_20_4 0 {Iload/Ncells}
Ic_20_5 n_20_5 0 {Iload/Ncells}
Ic_20_6 n_20_6 0 {Iload/Ncells}
Ic_20_7 n_20_7 0 {Iload/Ncells}
Ic_20_8 n_20_8 0 {Iload/Ncells}
Ic_20_9 n_20_9 0 {Iload/Ncells}
Ic_20_10 n_20_10 0 {Iload/Ncells}
Ic_20_11 n_20_11 0 {Iload/Ncells}
Ic_20_12 n_20_12 0 {Iload/Ncells}
Ic_20_13 n_20_13 0 {Iload/Ncells}
Ic_20_14 n_20_14 0 {Iload/Ncells}
Ic_20_15 n_20_15 0 {Iload/Ncells}
Ic_20_16 n_20_16 0 {Iload/Ncells}
Ic_20_17 n_20_17 0 {Iload/Ncells}
Ic_20_18 n_20_18 0 {Iload/Ncells}
Ic_20_19 n_20_19 0 {Iload/Ncells}
Ic_20_20 n_20_20 0 {Iload/Ncells}

*=========== Supply Stacks (49 pads) ===========
RSup_1 Vout n_2_2_h {Rsup}
RSup_2 Vout n_2_5_h {Rsup}
RSup_3 Vout n_2_8_h {Rsup}
RSup_4 Vout n_2_11_h {Rsup}
RSup_5 Vout n_2_14_h {Rsup}
RSup_6 Vout n_2_17_h {Rsup}
RSup_7 Vout n_2_20_h {Rsup}
RSup_8 Vout n_5_2_h {Rsup}
RSup_9 Vout n_5_5_h {Rsup}
RSup_10 Vout n_5_8_h {Rsup}
RSup_11 Vout n_5_11_h {Rsup}
RSup_12 Vout n_5_14_h {Rsup}
RSup_13 Vout n_5_17_h {Rsup}
RSup_14 Vout n_5_20_h {Rsup}
RSup_15 Vout n_8_2_h {Rsup}
RSup_16 Vout n_8_5_h {Rsup}
RSup_17 Vout n_8_8_h {Rsup}
RSup_18 Vout n_8_11_h {Rsup}
RSup_19 Vout n_8_14_h {Rsup}
RSup_20 Vout n_8_17_h {Rsup}
RSup_21 Vout n_8_20_h {Rsup}
RSup_22 Vout n_11_2_h {Rsup}
RSup_23 Vout n_11_5_h {Rsup}
RSup_24 Vout n_11_8_h {Rsup}
RSup_25 Vout n_11_11_h {Rsup}
RSup_26 Vout n_11_14_h {Rsup}
RSup_27 Vout n_11_17_h {Rsup}
RSup_28 Vout n_11_20_h {Rsup}
RSup_29 Vout n_14_2_h {Rsup}
RSup_30 Vout n_14_5_h {Rsup}
RSup_31 Vout n_14_8_h {Rsup}
RSup_32 Vout n_14_11_h {Rsup}
RSup_33 Vout n_14_14_h {Rsup}
RSup_34 Vout n_14_17_h {Rsup}
RSup_35 Vout n_14_20_h {Rsup}
RSup_36 Vout n_17_2_h {Rsup}
RSup_37 Vout n_17_5_h {Rsup}
RSup_38 Vout n_17_8_h {Rsup}
RSup_39 Vout n_17_11_h {Rsup}
RSup_40 Vout n_17_14_h {Rsup}
RSup_41 Vout n_17_17_h {Rsup}
RSup_42 Vout n_17_20_h {Rsup}
RSup_43 Vout n_20_2_h {Rsup}
RSup_44 Vout n_20_5_h {Rsup}
RSup_45 Vout n_20_8_h {Rsup}
RSup_46 Vout n_20_11_h {Rsup}
RSup_47 Vout n_20_14_h {Rsup}
RSup_48 Vout n_20_17_h {Rsup}
RSup_49 Vout n_20_20_h {Rsup}

*=========== Voltage Excitation + Analysis ===========
Vsupply Vout 0 {Vout_dc}
.op
.end
