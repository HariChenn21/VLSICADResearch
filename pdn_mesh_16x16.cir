* 16x16 Two-Layer Backside PDN Model
* Total cells: 256
* Interface: 'Vout' (connect to buck converter output)

*=========== Design Parameters ===========
.param Iload=4.54 PnTSV=4u tile=400u
.param Pb=57u alpha=3 Pp=150u
.param hVia=10u Dvia=50u

*=========== Per-Layer Resistance ===========
.param Nbpr={tile/0.105u}
.param Nseg={tile/PnTSV}
.param Rbpr={50*PnTSV/12/(Nbpr*Nseg)}
.param NnTSV={(tile/PnTSV)*(tile/(2*0.105u))}
.param RnTSV={2/NnTSV}
.param Lbsm1={2*PnTSV}
.param RsegBSM1={80m*Lbsm1/0.5u}
.param NsegBSM1={(tile/PnTSV)*(tile/(2*PnTSV))}
.param Rbsm1={RsegBSM1/12/NsegBSM1}
.param RtapOne={0.5*(2u/PnTSV)**2}
.param Ntap={(tile/(2*PnTSV))**2}
.param Rtap={RtapOne/Ntap}
.param Nbump={(tile/Pb)**2}
.param Rbsm3={40m/4/Nbump}
.param Rbump={10m/Nbump}
.param wBus={Pb*(alpha+1)/alpha}
.param Nbus={tile/Pp}
.param Rrdl3={2m*tile/wBus/3/Nbus}
.param RviaOne={1.68e-8*hVia/(3.14159*(Dvia/2)**2)}
.param Rvia={RviaOne/Nbump}
.param Npillar={(tile/Pp)**2}
.param Rrdl2={2m*0.25/Npillar}
.param Rrdl1={2m*0.25/Npillar}
.param RpillarOne={1.68e-8*120u/(3.14159*(75u/2)**2)}
.param Rpillar={RpillarOne/Npillar}

*=========== Mesh Aggregate (16x16) ===========
.param Ncells=256
.param Rlat=40m
.param Rsup={(Rpillar+Rrdl1+2*Rvia+Rrdl2+Rrdl3+Rbump)*4}
.param Rvia_cell={Rtap*Ncells}

*=========== Upper Layer Horizontal Laterals ===========
RH_1_1 n_1_1_h n_1_2_h {Rlat}
RH_1_2 n_1_2_h n_1_3_h {Rlat}
RH_1_3 n_1_3_h n_1_4_h {Rlat}
RH_1_4 n_1_4_h n_1_5_h {Rlat}
RH_1_5 n_1_5_h n_1_6_h {Rlat}
RH_1_6 n_1_6_h n_1_7_h {Rlat}
RH_1_7 n_1_7_h n_1_8_h {Rlat}
RH_1_8 n_1_8_h n_1_9_h {Rlat}
RH_1_9 n_1_9_h n_1_10_h {Rlat}
RH_1_10 n_1_10_h n_1_11_h {Rlat}
RH_1_11 n_1_11_h n_1_12_h {Rlat}
RH_1_12 n_1_12_h n_1_13_h {Rlat}
RH_1_13 n_1_13_h n_1_14_h {Rlat}
RH_1_14 n_1_14_h n_1_15_h {Rlat}
RH_1_15 n_1_15_h n_1_16_h {Rlat}
RH_2_1 n_2_1_h n_2_2_h {Rlat}
RH_2_2 n_2_2_h n_2_3_h {Rlat}
RH_2_3 n_2_3_h n_2_4_h {Rlat}
RH_2_4 n_2_4_h n_2_5_h {Rlat}
RH_2_5 n_2_5_h n_2_6_h {Rlat}
RH_2_6 n_2_6_h n_2_7_h {Rlat}
RH_2_7 n_2_7_h n_2_8_h {Rlat}
RH_2_8 n_2_8_h n_2_9_h {Rlat}
RH_2_9 n_2_9_h n_2_10_h {Rlat}
RH_2_10 n_2_10_h n_2_11_h {Rlat}
RH_2_11 n_2_11_h n_2_12_h {Rlat}
RH_2_12 n_2_12_h n_2_13_h {Rlat}
RH_2_13 n_2_13_h n_2_14_h {Rlat}
RH_2_14 n_2_14_h n_2_15_h {Rlat}
RH_2_15 n_2_15_h n_2_16_h {Rlat}
RH_3_1 n_3_1_h n_3_2_h {Rlat}
RH_3_2 n_3_2_h n_3_3_h {Rlat}
RH_3_3 n_3_3_h n_3_4_h {Rlat}
RH_3_4 n_3_4_h n_3_5_h {Rlat}
RH_3_5 n_3_5_h n_3_6_h {Rlat}
RH_3_6 n_3_6_h n_3_7_h {Rlat}
RH_3_7 n_3_7_h n_3_8_h {Rlat}
RH_3_8 n_3_8_h n_3_9_h {Rlat}
RH_3_9 n_3_9_h n_3_10_h {Rlat}
RH_3_10 n_3_10_h n_3_11_h {Rlat}
RH_3_11 n_3_11_h n_3_12_h {Rlat}
RH_3_12 n_3_12_h n_3_13_h {Rlat}
RH_3_13 n_3_13_h n_3_14_h {Rlat}
RH_3_14 n_3_14_h n_3_15_h {Rlat}
RH_3_15 n_3_15_h n_3_16_h {Rlat}
RH_4_1 n_4_1_h n_4_2_h {Rlat}
RH_4_2 n_4_2_h n_4_3_h {Rlat}
RH_4_3 n_4_3_h n_4_4_h {Rlat}
RH_4_4 n_4_4_h n_4_5_h {Rlat}
RH_4_5 n_4_5_h n_4_6_h {Rlat}
RH_4_6 n_4_6_h n_4_7_h {Rlat}
RH_4_7 n_4_7_h n_4_8_h {Rlat}
RH_4_8 n_4_8_h n_4_9_h {Rlat}
RH_4_9 n_4_9_h n_4_10_h {Rlat}
RH_4_10 n_4_10_h n_4_11_h {Rlat}
RH_4_11 n_4_11_h n_4_12_h {Rlat}
RH_4_12 n_4_12_h n_4_13_h {Rlat}
RH_4_13 n_4_13_h n_4_14_h {Rlat}
RH_4_14 n_4_14_h n_4_15_h {Rlat}
RH_4_15 n_4_15_h n_4_16_h {Rlat}
RH_5_1 n_5_1_h n_5_2_h {Rlat}
RH_5_2 n_5_2_h n_5_3_h {Rlat}
RH_5_3 n_5_3_h n_5_4_h {Rlat}
RH_5_4 n_5_4_h n_5_5_h {Rlat}
RH_5_5 n_5_5_h n_5_6_h {Rlat}
RH_5_6 n_5_6_h n_5_7_h {Rlat}
RH_5_7 n_5_7_h n_5_8_h {Rlat}
RH_5_8 n_5_8_h n_5_9_h {Rlat}
RH_5_9 n_5_9_h n_5_10_h {Rlat}
RH_5_10 n_5_10_h n_5_11_h {Rlat}
RH_5_11 n_5_11_h n_5_12_h {Rlat}
RH_5_12 n_5_12_h n_5_13_h {Rlat}
RH_5_13 n_5_13_h n_5_14_h {Rlat}
RH_5_14 n_5_14_h n_5_15_h {Rlat}
RH_5_15 n_5_15_h n_5_16_h {Rlat}
RH_6_1 n_6_1_h n_6_2_h {Rlat}
RH_6_2 n_6_2_h n_6_3_h {Rlat}
RH_6_3 n_6_3_h n_6_4_h {Rlat}
RH_6_4 n_6_4_h n_6_5_h {Rlat}
RH_6_5 n_6_5_h n_6_6_h {Rlat}
RH_6_6 n_6_6_h n_6_7_h {Rlat}
RH_6_7 n_6_7_h n_6_8_h {Rlat}
RH_6_8 n_6_8_h n_6_9_h {Rlat}
RH_6_9 n_6_9_h n_6_10_h {Rlat}
RH_6_10 n_6_10_h n_6_11_h {Rlat}
RH_6_11 n_6_11_h n_6_12_h {Rlat}
RH_6_12 n_6_12_h n_6_13_h {Rlat}
RH_6_13 n_6_13_h n_6_14_h {Rlat}
RH_6_14 n_6_14_h n_6_15_h {Rlat}
RH_6_15 n_6_15_h n_6_16_h {Rlat}
RH_7_1 n_7_1_h n_7_2_h {Rlat}
RH_7_2 n_7_2_h n_7_3_h {Rlat}
RH_7_3 n_7_3_h n_7_4_h {Rlat}
RH_7_4 n_7_4_h n_7_5_h {Rlat}
RH_7_5 n_7_5_h n_7_6_h {Rlat}
RH_7_6 n_7_6_h n_7_7_h {Rlat}
RH_7_7 n_7_7_h n_7_8_h {Rlat}
RH_7_8 n_7_8_h n_7_9_h {Rlat}
RH_7_9 n_7_9_h n_7_10_h {Rlat}
RH_7_10 n_7_10_h n_7_11_h {Rlat}
RH_7_11 n_7_11_h n_7_12_h {Rlat}
RH_7_12 n_7_12_h n_7_13_h {Rlat}
RH_7_13 n_7_13_h n_7_14_h {Rlat}
RH_7_14 n_7_14_h n_7_15_h {Rlat}
RH_7_15 n_7_15_h n_7_16_h {Rlat}
RH_8_1 n_8_1_h n_8_2_h {Rlat}
RH_8_2 n_8_2_h n_8_3_h {Rlat}
RH_8_3 n_8_3_h n_8_4_h {Rlat}
RH_8_4 n_8_4_h n_8_5_h {Rlat}
RH_8_5 n_8_5_h n_8_6_h {Rlat}
RH_8_6 n_8_6_h n_8_7_h {Rlat}
RH_8_7 n_8_7_h n_8_8_h {Rlat}
RH_8_8 n_8_8_h n_8_9_h {Rlat}
RH_8_9 n_8_9_h n_8_10_h {Rlat}
RH_8_10 n_8_10_h n_8_11_h {Rlat}
RH_8_11 n_8_11_h n_8_12_h {Rlat}
RH_8_12 n_8_12_h n_8_13_h {Rlat}
RH_8_13 n_8_13_h n_8_14_h {Rlat}
RH_8_14 n_8_14_h n_8_15_h {Rlat}
RH_8_15 n_8_15_h n_8_16_h {Rlat}
RH_9_1 n_9_1_h n_9_2_h {Rlat}
RH_9_2 n_9_2_h n_9_3_h {Rlat}
RH_9_3 n_9_3_h n_9_4_h {Rlat}
RH_9_4 n_9_4_h n_9_5_h {Rlat}
RH_9_5 n_9_5_h n_9_6_h {Rlat}
RH_9_6 n_9_6_h n_9_7_h {Rlat}
RH_9_7 n_9_7_h n_9_8_h {Rlat}
RH_9_8 n_9_8_h n_9_9_h {Rlat}
RH_9_9 n_9_9_h n_9_10_h {Rlat}
RH_9_10 n_9_10_h n_9_11_h {Rlat}
RH_9_11 n_9_11_h n_9_12_h {Rlat}
RH_9_12 n_9_12_h n_9_13_h {Rlat}
RH_9_13 n_9_13_h n_9_14_h {Rlat}
RH_9_14 n_9_14_h n_9_15_h {Rlat}
RH_9_15 n_9_15_h n_9_16_h {Rlat}
RH_10_1 n_10_1_h n_10_2_h {Rlat}
RH_10_2 n_10_2_h n_10_3_h {Rlat}
RH_10_3 n_10_3_h n_10_4_h {Rlat}
RH_10_4 n_10_4_h n_10_5_h {Rlat}
RH_10_5 n_10_5_h n_10_6_h {Rlat}
RH_10_6 n_10_6_h n_10_7_h {Rlat}
RH_10_7 n_10_7_h n_10_8_h {Rlat}
RH_10_8 n_10_8_h n_10_9_h {Rlat}
RH_10_9 n_10_9_h n_10_10_h {Rlat}
RH_10_10 n_10_10_h n_10_11_h {Rlat}
RH_10_11 n_10_11_h n_10_12_h {Rlat}
RH_10_12 n_10_12_h n_10_13_h {Rlat}
RH_10_13 n_10_13_h n_10_14_h {Rlat}
RH_10_14 n_10_14_h n_10_15_h {Rlat}
RH_10_15 n_10_15_h n_10_16_h {Rlat}
RH_11_1 n_11_1_h n_11_2_h {Rlat}
RH_11_2 n_11_2_h n_11_3_h {Rlat}
RH_11_3 n_11_3_h n_11_4_h {Rlat}
RH_11_4 n_11_4_h n_11_5_h {Rlat}
RH_11_5 n_11_5_h n_11_6_h {Rlat}
RH_11_6 n_11_6_h n_11_7_h {Rlat}
RH_11_7 n_11_7_h n_11_8_h {Rlat}
RH_11_8 n_11_8_h n_11_9_h {Rlat}
RH_11_9 n_11_9_h n_11_10_h {Rlat}
RH_11_10 n_11_10_h n_11_11_h {Rlat}
RH_11_11 n_11_11_h n_11_12_h {Rlat}
RH_11_12 n_11_12_h n_11_13_h {Rlat}
RH_11_13 n_11_13_h n_11_14_h {Rlat}
RH_11_14 n_11_14_h n_11_15_h {Rlat}
RH_11_15 n_11_15_h n_11_16_h {Rlat}
RH_12_1 n_12_1_h n_12_2_h {Rlat}
RH_12_2 n_12_2_h n_12_3_h {Rlat}
RH_12_3 n_12_3_h n_12_4_h {Rlat}
RH_12_4 n_12_4_h n_12_5_h {Rlat}
RH_12_5 n_12_5_h n_12_6_h {Rlat}
RH_12_6 n_12_6_h n_12_7_h {Rlat}
RH_12_7 n_12_7_h n_12_8_h {Rlat}
RH_12_8 n_12_8_h n_12_9_h {Rlat}
RH_12_9 n_12_9_h n_12_10_h {Rlat}
RH_12_10 n_12_10_h n_12_11_h {Rlat}
RH_12_11 n_12_11_h n_12_12_h {Rlat}
RH_12_12 n_12_12_h n_12_13_h {Rlat}
RH_12_13 n_12_13_h n_12_14_h {Rlat}
RH_12_14 n_12_14_h n_12_15_h {Rlat}
RH_12_15 n_12_15_h n_12_16_h {Rlat}
RH_13_1 n_13_1_h n_13_2_h {Rlat}
RH_13_2 n_13_2_h n_13_3_h {Rlat}
RH_13_3 n_13_3_h n_13_4_h {Rlat}
RH_13_4 n_13_4_h n_13_5_h {Rlat}
RH_13_5 n_13_5_h n_13_6_h {Rlat}
RH_13_6 n_13_6_h n_13_7_h {Rlat}
RH_13_7 n_13_7_h n_13_8_h {Rlat}
RH_13_8 n_13_8_h n_13_9_h {Rlat}
RH_13_9 n_13_9_h n_13_10_h {Rlat}
RH_13_10 n_13_10_h n_13_11_h {Rlat}
RH_13_11 n_13_11_h n_13_12_h {Rlat}
RH_13_12 n_13_12_h n_13_13_h {Rlat}
RH_13_13 n_13_13_h n_13_14_h {Rlat}
RH_13_14 n_13_14_h n_13_15_h {Rlat}
RH_13_15 n_13_15_h n_13_16_h {Rlat}
RH_14_1 n_14_1_h n_14_2_h {Rlat}
RH_14_2 n_14_2_h n_14_3_h {Rlat}
RH_14_3 n_14_3_h n_14_4_h {Rlat}
RH_14_4 n_14_4_h n_14_5_h {Rlat}
RH_14_5 n_14_5_h n_14_6_h {Rlat}
RH_14_6 n_14_6_h n_14_7_h {Rlat}
RH_14_7 n_14_7_h n_14_8_h {Rlat}
RH_14_8 n_14_8_h n_14_9_h {Rlat}
RH_14_9 n_14_9_h n_14_10_h {Rlat}
RH_14_10 n_14_10_h n_14_11_h {Rlat}
RH_14_11 n_14_11_h n_14_12_h {Rlat}
RH_14_12 n_14_12_h n_14_13_h {Rlat}
RH_14_13 n_14_13_h n_14_14_h {Rlat}
RH_14_14 n_14_14_h n_14_15_h {Rlat}
RH_14_15 n_14_15_h n_14_16_h {Rlat}
RH_15_1 n_15_1_h n_15_2_h {Rlat}
RH_15_2 n_15_2_h n_15_3_h {Rlat}
RH_15_3 n_15_3_h n_15_4_h {Rlat}
RH_15_4 n_15_4_h n_15_5_h {Rlat}
RH_15_5 n_15_5_h n_15_6_h {Rlat}
RH_15_6 n_15_6_h n_15_7_h {Rlat}
RH_15_7 n_15_7_h n_15_8_h {Rlat}
RH_15_8 n_15_8_h n_15_9_h {Rlat}
RH_15_9 n_15_9_h n_15_10_h {Rlat}
RH_15_10 n_15_10_h n_15_11_h {Rlat}
RH_15_11 n_15_11_h n_15_12_h {Rlat}
RH_15_12 n_15_12_h n_15_13_h {Rlat}
RH_15_13 n_15_13_h n_15_14_h {Rlat}
RH_15_14 n_15_14_h n_15_15_h {Rlat}
RH_15_15 n_15_15_h n_15_16_h {Rlat}
RH_16_1 n_16_1_h n_16_2_h {Rlat}
RH_16_2 n_16_2_h n_16_3_h {Rlat}
RH_16_3 n_16_3_h n_16_4_h {Rlat}
RH_16_4 n_16_4_h n_16_5_h {Rlat}
RH_16_5 n_16_5_h n_16_6_h {Rlat}
RH_16_6 n_16_6_h n_16_7_h {Rlat}
RH_16_7 n_16_7_h n_16_8_h {Rlat}
RH_16_8 n_16_8_h n_16_9_h {Rlat}
RH_16_9 n_16_9_h n_16_10_h {Rlat}
RH_16_10 n_16_10_h n_16_11_h {Rlat}
RH_16_11 n_16_11_h n_16_12_h {Rlat}
RH_16_12 n_16_12_h n_16_13_h {Rlat}
RH_16_13 n_16_13_h n_16_14_h {Rlat}
RH_16_14 n_16_14_h n_16_15_h {Rlat}
RH_16_15 n_16_15_h n_16_16_h {Rlat}

*=========== Lower Layer Vertical Laterals ===========
RV_1_1 n_1_1 n_2_1 {Rlat}
RV_1_2 n_1_2 n_2_2 {Rlat}
RV_1_3 n_1_3 n_2_3 {Rlat}
RV_1_4 n_1_4 n_2_4 {Rlat}
RV_1_5 n_1_5 n_2_5 {Rlat}
RV_1_6 n_1_6 n_2_6 {Rlat}
RV_1_7 n_1_7 n_2_7 {Rlat}
RV_1_8 n_1_8 n_2_8 {Rlat}
RV_1_9 n_1_9 n_2_9 {Rlat}
RV_1_10 n_1_10 n_2_10 {Rlat}
RV_1_11 n_1_11 n_2_11 {Rlat}
RV_1_12 n_1_12 n_2_12 {Rlat}
RV_1_13 n_1_13 n_2_13 {Rlat}
RV_1_14 n_1_14 n_2_14 {Rlat}
RV_1_15 n_1_15 n_2_15 {Rlat}
RV_1_16 n_1_16 n_2_16 {Rlat}
RV_2_1 n_2_1 n_3_1 {Rlat}
RV_2_2 n_2_2 n_3_2 {Rlat}
RV_2_3 n_2_3 n_3_3 {Rlat}
RV_2_4 n_2_4 n_3_4 {Rlat}
RV_2_5 n_2_5 n_3_5 {Rlat}
RV_2_6 n_2_6 n_3_6 {Rlat}
RV_2_7 n_2_7 n_3_7 {Rlat}
RV_2_8 n_2_8 n_3_8 {Rlat}
RV_2_9 n_2_9 n_3_9 {Rlat}
RV_2_10 n_2_10 n_3_10 {Rlat}
RV_2_11 n_2_11 n_3_11 {Rlat}
RV_2_12 n_2_12 n_3_12 {Rlat}
RV_2_13 n_2_13 n_3_13 {Rlat}
RV_2_14 n_2_14 n_3_14 {Rlat}
RV_2_15 n_2_15 n_3_15 {Rlat}
RV_2_16 n_2_16 n_3_16 {Rlat}
RV_3_1 n_3_1 n_4_1 {Rlat}
RV_3_2 n_3_2 n_4_2 {Rlat}
RV_3_3 n_3_3 n_4_3 {Rlat}
RV_3_4 n_3_4 n_4_4 {Rlat}
RV_3_5 n_3_5 n_4_5 {Rlat}
RV_3_6 n_3_6 n_4_6 {Rlat}
RV_3_7 n_3_7 n_4_7 {Rlat}
RV_3_8 n_3_8 n_4_8 {Rlat}
RV_3_9 n_3_9 n_4_9 {Rlat}
RV_3_10 n_3_10 n_4_10 {Rlat}
RV_3_11 n_3_11 n_4_11 {Rlat}
RV_3_12 n_3_12 n_4_12 {Rlat}
RV_3_13 n_3_13 n_4_13 {Rlat}
RV_3_14 n_3_14 n_4_14 {Rlat}
RV_3_15 n_3_15 n_4_15 {Rlat}
RV_3_16 n_3_16 n_4_16 {Rlat}
RV_4_1 n_4_1 n_5_1 {Rlat}
RV_4_2 n_4_2 n_5_2 {Rlat}
RV_4_3 n_4_3 n_5_3 {Rlat}
RV_4_4 n_4_4 n_5_4 {Rlat}
RV_4_5 n_4_5 n_5_5 {Rlat}
RV_4_6 n_4_6 n_5_6 {Rlat}
RV_4_7 n_4_7 n_5_7 {Rlat}
RV_4_8 n_4_8 n_5_8 {Rlat}
RV_4_9 n_4_9 n_5_9 {Rlat}
RV_4_10 n_4_10 n_5_10 {Rlat}
RV_4_11 n_4_11 n_5_11 {Rlat}
RV_4_12 n_4_12 n_5_12 {Rlat}
RV_4_13 n_4_13 n_5_13 {Rlat}
RV_4_14 n_4_14 n_5_14 {Rlat}
RV_4_15 n_4_15 n_5_15 {Rlat}
RV_4_16 n_4_16 n_5_16 {Rlat}
RV_5_1 n_5_1 n_6_1 {Rlat}
RV_5_2 n_5_2 n_6_2 {Rlat}
RV_5_3 n_5_3 n_6_3 {Rlat}
RV_5_4 n_5_4 n_6_4 {Rlat}
RV_5_5 n_5_5 n_6_5 {Rlat}
RV_5_6 n_5_6 n_6_6 {Rlat}
RV_5_7 n_5_7 n_6_7 {Rlat}
RV_5_8 n_5_8 n_6_8 {Rlat}
RV_5_9 n_5_9 n_6_9 {Rlat}
RV_5_10 n_5_10 n_6_10 {Rlat}
RV_5_11 n_5_11 n_6_11 {Rlat}
RV_5_12 n_5_12 n_6_12 {Rlat}
RV_5_13 n_5_13 n_6_13 {Rlat}
RV_5_14 n_5_14 n_6_14 {Rlat}
RV_5_15 n_5_15 n_6_15 {Rlat}
RV_5_16 n_5_16 n_6_16 {Rlat}
RV_6_1 n_6_1 n_7_1 {Rlat}
RV_6_2 n_6_2 n_7_2 {Rlat}
RV_6_3 n_6_3 n_7_3 {Rlat}
RV_6_4 n_6_4 n_7_4 {Rlat}
RV_6_5 n_6_5 n_7_5 {Rlat}
RV_6_6 n_6_6 n_7_6 {Rlat}
RV_6_7 n_6_7 n_7_7 {Rlat}
RV_6_8 n_6_8 n_7_8 {Rlat}
RV_6_9 n_6_9 n_7_9 {Rlat}
RV_6_10 n_6_10 n_7_10 {Rlat}
RV_6_11 n_6_11 n_7_11 {Rlat}
RV_6_12 n_6_12 n_7_12 {Rlat}
RV_6_13 n_6_13 n_7_13 {Rlat}
RV_6_14 n_6_14 n_7_14 {Rlat}
RV_6_15 n_6_15 n_7_15 {Rlat}
RV_6_16 n_6_16 n_7_16 {Rlat}
RV_7_1 n_7_1 n_8_1 {Rlat}
RV_7_2 n_7_2 n_8_2 {Rlat}
RV_7_3 n_7_3 n_8_3 {Rlat}
RV_7_4 n_7_4 n_8_4 {Rlat}
RV_7_5 n_7_5 n_8_5 {Rlat}
RV_7_6 n_7_6 n_8_6 {Rlat}
RV_7_7 n_7_7 n_8_7 {Rlat}
RV_7_8 n_7_8 n_8_8 {Rlat}
RV_7_9 n_7_9 n_8_9 {Rlat}
RV_7_10 n_7_10 n_8_10 {Rlat}
RV_7_11 n_7_11 n_8_11 {Rlat}
RV_7_12 n_7_12 n_8_12 {Rlat}
RV_7_13 n_7_13 n_8_13 {Rlat}
RV_7_14 n_7_14 n_8_14 {Rlat}
RV_7_15 n_7_15 n_8_15 {Rlat}
RV_7_16 n_7_16 n_8_16 {Rlat}
RV_8_1 n_8_1 n_9_1 {Rlat}
RV_8_2 n_8_2 n_9_2 {Rlat}
RV_8_3 n_8_3 n_9_3 {Rlat}
RV_8_4 n_8_4 n_9_4 {Rlat}
RV_8_5 n_8_5 n_9_5 {Rlat}
RV_8_6 n_8_6 n_9_6 {Rlat}
RV_8_7 n_8_7 n_9_7 {Rlat}
RV_8_8 n_8_8 n_9_8 {Rlat}
RV_8_9 n_8_9 n_9_9 {Rlat}
RV_8_10 n_8_10 n_9_10 {Rlat}
RV_8_11 n_8_11 n_9_11 {Rlat}
RV_8_12 n_8_12 n_9_12 {Rlat}
RV_8_13 n_8_13 n_9_13 {Rlat}
RV_8_14 n_8_14 n_9_14 {Rlat}
RV_8_15 n_8_15 n_9_15 {Rlat}
RV_8_16 n_8_16 n_9_16 {Rlat}
RV_9_1 n_9_1 n_10_1 {Rlat}
RV_9_2 n_9_2 n_10_2 {Rlat}
RV_9_3 n_9_3 n_10_3 {Rlat}
RV_9_4 n_9_4 n_10_4 {Rlat}
RV_9_5 n_9_5 n_10_5 {Rlat}
RV_9_6 n_9_6 n_10_6 {Rlat}
RV_9_7 n_9_7 n_10_7 {Rlat}
RV_9_8 n_9_8 n_10_8 {Rlat}
RV_9_9 n_9_9 n_10_9 {Rlat}
RV_9_10 n_9_10 n_10_10 {Rlat}
RV_9_11 n_9_11 n_10_11 {Rlat}
RV_9_12 n_9_12 n_10_12 {Rlat}
RV_9_13 n_9_13 n_10_13 {Rlat}
RV_9_14 n_9_14 n_10_14 {Rlat}
RV_9_15 n_9_15 n_10_15 {Rlat}
RV_9_16 n_9_16 n_10_16 {Rlat}
RV_10_1 n_10_1 n_11_1 {Rlat}
RV_10_2 n_10_2 n_11_2 {Rlat}
RV_10_3 n_10_3 n_11_3 {Rlat}
RV_10_4 n_10_4 n_11_4 {Rlat}
RV_10_5 n_10_5 n_11_5 {Rlat}
RV_10_6 n_10_6 n_11_6 {Rlat}
RV_10_7 n_10_7 n_11_7 {Rlat}
RV_10_8 n_10_8 n_11_8 {Rlat}
RV_10_9 n_10_9 n_11_9 {Rlat}
RV_10_10 n_10_10 n_11_10 {Rlat}
RV_10_11 n_10_11 n_11_11 {Rlat}
RV_10_12 n_10_12 n_11_12 {Rlat}
RV_10_13 n_10_13 n_11_13 {Rlat}
RV_10_14 n_10_14 n_11_14 {Rlat}
RV_10_15 n_10_15 n_11_15 {Rlat}
RV_10_16 n_10_16 n_11_16 {Rlat}
RV_11_1 n_11_1 n_12_1 {Rlat}
RV_11_2 n_11_2 n_12_2 {Rlat}
RV_11_3 n_11_3 n_12_3 {Rlat}
RV_11_4 n_11_4 n_12_4 {Rlat}
RV_11_5 n_11_5 n_12_5 {Rlat}
RV_11_6 n_11_6 n_12_6 {Rlat}
RV_11_7 n_11_7 n_12_7 {Rlat}
RV_11_8 n_11_8 n_12_8 {Rlat}
RV_11_9 n_11_9 n_12_9 {Rlat}
RV_11_10 n_11_10 n_12_10 {Rlat}
RV_11_11 n_11_11 n_12_11 {Rlat}
RV_11_12 n_11_12 n_12_12 {Rlat}
RV_11_13 n_11_13 n_12_13 {Rlat}
RV_11_14 n_11_14 n_12_14 {Rlat}
RV_11_15 n_11_15 n_12_15 {Rlat}
RV_11_16 n_11_16 n_12_16 {Rlat}
RV_12_1 n_12_1 n_13_1 {Rlat}
RV_12_2 n_12_2 n_13_2 {Rlat}
RV_12_3 n_12_3 n_13_3 {Rlat}
RV_12_4 n_12_4 n_13_4 {Rlat}
RV_12_5 n_12_5 n_13_5 {Rlat}
RV_12_6 n_12_6 n_13_6 {Rlat}
RV_12_7 n_12_7 n_13_7 {Rlat}
RV_12_8 n_12_8 n_13_8 {Rlat}
RV_12_9 n_12_9 n_13_9 {Rlat}
RV_12_10 n_12_10 n_13_10 {Rlat}
RV_12_11 n_12_11 n_13_11 {Rlat}
RV_12_12 n_12_12 n_13_12 {Rlat}
RV_12_13 n_12_13 n_13_13 {Rlat}
RV_12_14 n_12_14 n_13_14 {Rlat}
RV_12_15 n_12_15 n_13_15 {Rlat}
RV_12_16 n_12_16 n_13_16 {Rlat}
RV_13_1 n_13_1 n_14_1 {Rlat}
RV_13_2 n_13_2 n_14_2 {Rlat}
RV_13_3 n_13_3 n_14_3 {Rlat}
RV_13_4 n_13_4 n_14_4 {Rlat}
RV_13_5 n_13_5 n_14_5 {Rlat}
RV_13_6 n_13_6 n_14_6 {Rlat}
RV_13_7 n_13_7 n_14_7 {Rlat}
RV_13_8 n_13_8 n_14_8 {Rlat}
RV_13_9 n_13_9 n_14_9 {Rlat}
RV_13_10 n_13_10 n_14_10 {Rlat}
RV_13_11 n_13_11 n_14_11 {Rlat}
RV_13_12 n_13_12 n_14_12 {Rlat}
RV_13_13 n_13_13 n_14_13 {Rlat}
RV_13_14 n_13_14 n_14_14 {Rlat}
RV_13_15 n_13_15 n_14_15 {Rlat}
RV_13_16 n_13_16 n_14_16 {Rlat}
RV_14_1 n_14_1 n_15_1 {Rlat}
RV_14_2 n_14_2 n_15_2 {Rlat}
RV_14_3 n_14_3 n_15_3 {Rlat}
RV_14_4 n_14_4 n_15_4 {Rlat}
RV_14_5 n_14_5 n_15_5 {Rlat}
RV_14_6 n_14_6 n_15_6 {Rlat}
RV_14_7 n_14_7 n_15_7 {Rlat}
RV_14_8 n_14_8 n_15_8 {Rlat}
RV_14_9 n_14_9 n_15_9 {Rlat}
RV_14_10 n_14_10 n_15_10 {Rlat}
RV_14_11 n_14_11 n_15_11 {Rlat}
RV_14_12 n_14_12 n_15_12 {Rlat}
RV_14_13 n_14_13 n_15_13 {Rlat}
RV_14_14 n_14_14 n_15_14 {Rlat}
RV_14_15 n_14_15 n_15_15 {Rlat}
RV_14_16 n_14_16 n_15_16 {Rlat}
RV_15_1 n_15_1 n_16_1 {Rlat}
RV_15_2 n_15_2 n_16_2 {Rlat}
RV_15_3 n_15_3 n_16_3 {Rlat}
RV_15_4 n_15_4 n_16_4 {Rlat}
RV_15_5 n_15_5 n_16_5 {Rlat}
RV_15_6 n_15_6 n_16_6 {Rlat}
RV_15_7 n_15_7 n_16_7 {Rlat}
RV_15_8 n_15_8 n_16_8 {Rlat}
RV_15_9 n_15_9 n_16_9 {Rlat}
RV_15_10 n_15_10 n_16_10 {Rlat}
RV_15_11 n_15_11 n_16_11 {Rlat}
RV_15_12 n_15_12 n_16_12 {Rlat}
RV_15_13 n_15_13 n_16_13 {Rlat}
RV_15_14 n_15_14 n_16_14 {Rlat}
RV_15_15 n_15_15 n_16_15 {Rlat}
RV_15_16 n_15_16 n_16_16 {Rlat}

*=========== Vias (Upper <-> Lower) ===========
RVia_1_1 n_1_1_h n_1_1 {Rvia_cell}
RVia_1_2 n_1_2_h n_1_2 {Rvia_cell}
RVia_1_3 n_1_3_h n_1_3 {Rvia_cell}
RVia_1_4 n_1_4_h n_1_4 {Rvia_cell}
RVia_1_5 n_1_5_h n_1_5 {Rvia_cell}
RVia_1_6 n_1_6_h n_1_6 {Rvia_cell}
RVia_1_7 n_1_7_h n_1_7 {Rvia_cell}
RVia_1_8 n_1_8_h n_1_8 {Rvia_cell}
RVia_1_9 n_1_9_h n_1_9 {Rvia_cell}
RVia_1_10 n_1_10_h n_1_10 {Rvia_cell}
RVia_1_11 n_1_11_h n_1_11 {Rvia_cell}
RVia_1_12 n_1_12_h n_1_12 {Rvia_cell}
RVia_1_13 n_1_13_h n_1_13 {Rvia_cell}
RVia_1_14 n_1_14_h n_1_14 {Rvia_cell}
RVia_1_15 n_1_15_h n_1_15 {Rvia_cell}
RVia_1_16 n_1_16_h n_1_16 {Rvia_cell}
RVia_2_1 n_2_1_h n_2_1 {Rvia_cell}
RVia_2_2 n_2_2_h n_2_2 {Rvia_cell}
RVia_2_3 n_2_3_h n_2_3 {Rvia_cell}
RVia_2_4 n_2_4_h n_2_4 {Rvia_cell}
RVia_2_5 n_2_5_h n_2_5 {Rvia_cell}
RVia_2_6 n_2_6_h n_2_6 {Rvia_cell}
RVia_2_7 n_2_7_h n_2_7 {Rvia_cell}
RVia_2_8 n_2_8_h n_2_8 {Rvia_cell}
RVia_2_9 n_2_9_h n_2_9 {Rvia_cell}
RVia_2_10 n_2_10_h n_2_10 {Rvia_cell}
RVia_2_11 n_2_11_h n_2_11 {Rvia_cell}
RVia_2_12 n_2_12_h n_2_12 {Rvia_cell}
RVia_2_13 n_2_13_h n_2_13 {Rvia_cell}
RVia_2_14 n_2_14_h n_2_14 {Rvia_cell}
RVia_2_15 n_2_15_h n_2_15 {Rvia_cell}
RVia_2_16 n_2_16_h n_2_16 {Rvia_cell}
RVia_3_1 n_3_1_h n_3_1 {Rvia_cell}
RVia_3_2 n_3_2_h n_3_2 {Rvia_cell}
RVia_3_3 n_3_3_h n_3_3 {Rvia_cell}
RVia_3_4 n_3_4_h n_3_4 {Rvia_cell}
RVia_3_5 n_3_5_h n_3_5 {Rvia_cell}
RVia_3_6 n_3_6_h n_3_6 {Rvia_cell}
RVia_3_7 n_3_7_h n_3_7 {Rvia_cell}
RVia_3_8 n_3_8_h n_3_8 {Rvia_cell}
RVia_3_9 n_3_9_h n_3_9 {Rvia_cell}
RVia_3_10 n_3_10_h n_3_10 {Rvia_cell}
RVia_3_11 n_3_11_h n_3_11 {Rvia_cell}
RVia_3_12 n_3_12_h n_3_12 {Rvia_cell}
RVia_3_13 n_3_13_h n_3_13 {Rvia_cell}
RVia_3_14 n_3_14_h n_3_14 {Rvia_cell}
RVia_3_15 n_3_15_h n_3_15 {Rvia_cell}
RVia_3_16 n_3_16_h n_3_16 {Rvia_cell}
RVia_4_1 n_4_1_h n_4_1 {Rvia_cell}
RVia_4_2 n_4_2_h n_4_2 {Rvia_cell}
RVia_4_3 n_4_3_h n_4_3 {Rvia_cell}
RVia_4_4 n_4_4_h n_4_4 {Rvia_cell}
RVia_4_5 n_4_5_h n_4_5 {Rvia_cell}
RVia_4_6 n_4_6_h n_4_6 {Rvia_cell}
RVia_4_7 n_4_7_h n_4_7 {Rvia_cell}
RVia_4_8 n_4_8_h n_4_8 {Rvia_cell}
RVia_4_9 n_4_9_h n_4_9 {Rvia_cell}
RVia_4_10 n_4_10_h n_4_10 {Rvia_cell}
RVia_4_11 n_4_11_h n_4_11 {Rvia_cell}
RVia_4_12 n_4_12_h n_4_12 {Rvia_cell}
RVia_4_13 n_4_13_h n_4_13 {Rvia_cell}
RVia_4_14 n_4_14_h n_4_14 {Rvia_cell}
RVia_4_15 n_4_15_h n_4_15 {Rvia_cell}
RVia_4_16 n_4_16_h n_4_16 {Rvia_cell}
RVia_5_1 n_5_1_h n_5_1 {Rvia_cell}
RVia_5_2 n_5_2_h n_5_2 {Rvia_cell}
RVia_5_3 n_5_3_h n_5_3 {Rvia_cell}
RVia_5_4 n_5_4_h n_5_4 {Rvia_cell}
RVia_5_5 n_5_5_h n_5_5 {Rvia_cell}
RVia_5_6 n_5_6_h n_5_6 {Rvia_cell}
RVia_5_7 n_5_7_h n_5_7 {Rvia_cell}
RVia_5_8 n_5_8_h n_5_8 {Rvia_cell}
RVia_5_9 n_5_9_h n_5_9 {Rvia_cell}
RVia_5_10 n_5_10_h n_5_10 {Rvia_cell}
RVia_5_11 n_5_11_h n_5_11 {Rvia_cell}
RVia_5_12 n_5_12_h n_5_12 {Rvia_cell}
RVia_5_13 n_5_13_h n_5_13 {Rvia_cell}
RVia_5_14 n_5_14_h n_5_14 {Rvia_cell}
RVia_5_15 n_5_15_h n_5_15 {Rvia_cell}
RVia_5_16 n_5_16_h n_5_16 {Rvia_cell}
RVia_6_1 n_6_1_h n_6_1 {Rvia_cell}
RVia_6_2 n_6_2_h n_6_2 {Rvia_cell}
RVia_6_3 n_6_3_h n_6_3 {Rvia_cell}
RVia_6_4 n_6_4_h n_6_4 {Rvia_cell}
RVia_6_5 n_6_5_h n_6_5 {Rvia_cell}
RVia_6_6 n_6_6_h n_6_6 {Rvia_cell}
RVia_6_7 n_6_7_h n_6_7 {Rvia_cell}
RVia_6_8 n_6_8_h n_6_8 {Rvia_cell}
RVia_6_9 n_6_9_h n_6_9 {Rvia_cell}
RVia_6_10 n_6_10_h n_6_10 {Rvia_cell}
RVia_6_11 n_6_11_h n_6_11 {Rvia_cell}
RVia_6_12 n_6_12_h n_6_12 {Rvia_cell}
RVia_6_13 n_6_13_h n_6_13 {Rvia_cell}
RVia_6_14 n_6_14_h n_6_14 {Rvia_cell}
RVia_6_15 n_6_15_h n_6_15 {Rvia_cell}
RVia_6_16 n_6_16_h n_6_16 {Rvia_cell}
RVia_7_1 n_7_1_h n_7_1 {Rvia_cell}
RVia_7_2 n_7_2_h n_7_2 {Rvia_cell}
RVia_7_3 n_7_3_h n_7_3 {Rvia_cell}
RVia_7_4 n_7_4_h n_7_4 {Rvia_cell}
RVia_7_5 n_7_5_h n_7_5 {Rvia_cell}
RVia_7_6 n_7_6_h n_7_6 {Rvia_cell}
RVia_7_7 n_7_7_h n_7_7 {Rvia_cell}
RVia_7_8 n_7_8_h n_7_8 {Rvia_cell}
RVia_7_9 n_7_9_h n_7_9 {Rvia_cell}
RVia_7_10 n_7_10_h n_7_10 {Rvia_cell}
RVia_7_11 n_7_11_h n_7_11 {Rvia_cell}
RVia_7_12 n_7_12_h n_7_12 {Rvia_cell}
RVia_7_13 n_7_13_h n_7_13 {Rvia_cell}
RVia_7_14 n_7_14_h n_7_14 {Rvia_cell}
RVia_7_15 n_7_15_h n_7_15 {Rvia_cell}
RVia_7_16 n_7_16_h n_7_16 {Rvia_cell}
RVia_8_1 n_8_1_h n_8_1 {Rvia_cell}
RVia_8_2 n_8_2_h n_8_2 {Rvia_cell}
RVia_8_3 n_8_3_h n_8_3 {Rvia_cell}
RVia_8_4 n_8_4_h n_8_4 {Rvia_cell}
RVia_8_5 n_8_5_h n_8_5 {Rvia_cell}
RVia_8_6 n_8_6_h n_8_6 {Rvia_cell}
RVia_8_7 n_8_7_h n_8_7 {Rvia_cell}
RVia_8_8 n_8_8_h n_8_8 {Rvia_cell}
RVia_8_9 n_8_9_h n_8_9 {Rvia_cell}
RVia_8_10 n_8_10_h n_8_10 {Rvia_cell}
RVia_8_11 n_8_11_h n_8_11 {Rvia_cell}
RVia_8_12 n_8_12_h n_8_12 {Rvia_cell}
RVia_8_13 n_8_13_h n_8_13 {Rvia_cell}
RVia_8_14 n_8_14_h n_8_14 {Rvia_cell}
RVia_8_15 n_8_15_h n_8_15 {Rvia_cell}
RVia_8_16 n_8_16_h n_8_16 {Rvia_cell}
RVia_9_1 n_9_1_h n_9_1 {Rvia_cell}
RVia_9_2 n_9_2_h n_9_2 {Rvia_cell}
RVia_9_3 n_9_3_h n_9_3 {Rvia_cell}
RVia_9_4 n_9_4_h n_9_4 {Rvia_cell}
RVia_9_5 n_9_5_h n_9_5 {Rvia_cell}
RVia_9_6 n_9_6_h n_9_6 {Rvia_cell}
RVia_9_7 n_9_7_h n_9_7 {Rvia_cell}
RVia_9_8 n_9_8_h n_9_8 {Rvia_cell}
RVia_9_9 n_9_9_h n_9_9 {Rvia_cell}
RVia_9_10 n_9_10_h n_9_10 {Rvia_cell}
RVia_9_11 n_9_11_h n_9_11 {Rvia_cell}
RVia_9_12 n_9_12_h n_9_12 {Rvia_cell}
RVia_9_13 n_9_13_h n_9_13 {Rvia_cell}
RVia_9_14 n_9_14_h n_9_14 {Rvia_cell}
RVia_9_15 n_9_15_h n_9_15 {Rvia_cell}
RVia_9_16 n_9_16_h n_9_16 {Rvia_cell}
RVia_10_1 n_10_1_h n_10_1 {Rvia_cell}
RVia_10_2 n_10_2_h n_10_2 {Rvia_cell}
RVia_10_3 n_10_3_h n_10_3 {Rvia_cell}
RVia_10_4 n_10_4_h n_10_4 {Rvia_cell}
RVia_10_5 n_10_5_h n_10_5 {Rvia_cell}
RVia_10_6 n_10_6_h n_10_6 {Rvia_cell}
RVia_10_7 n_10_7_h n_10_7 {Rvia_cell}
RVia_10_8 n_10_8_h n_10_8 {Rvia_cell}
RVia_10_9 n_10_9_h n_10_9 {Rvia_cell}
RVia_10_10 n_10_10_h n_10_10 {Rvia_cell}
RVia_10_11 n_10_11_h n_10_11 {Rvia_cell}
RVia_10_12 n_10_12_h n_10_12 {Rvia_cell}
RVia_10_13 n_10_13_h n_10_13 {Rvia_cell}
RVia_10_14 n_10_14_h n_10_14 {Rvia_cell}
RVia_10_15 n_10_15_h n_10_15 {Rvia_cell}
RVia_10_16 n_10_16_h n_10_16 {Rvia_cell}
RVia_11_1 n_11_1_h n_11_1 {Rvia_cell}
RVia_11_2 n_11_2_h n_11_2 {Rvia_cell}
RVia_11_3 n_11_3_h n_11_3 {Rvia_cell}
RVia_11_4 n_11_4_h n_11_4 {Rvia_cell}
RVia_11_5 n_11_5_h n_11_5 {Rvia_cell}
RVia_11_6 n_11_6_h n_11_6 {Rvia_cell}
RVia_11_7 n_11_7_h n_11_7 {Rvia_cell}
RVia_11_8 n_11_8_h n_11_8 {Rvia_cell}
RVia_11_9 n_11_9_h n_11_9 {Rvia_cell}
RVia_11_10 n_11_10_h n_11_10 {Rvia_cell}
RVia_11_11 n_11_11_h n_11_11 {Rvia_cell}
RVia_11_12 n_11_12_h n_11_12 {Rvia_cell}
RVia_11_13 n_11_13_h n_11_13 {Rvia_cell}
RVia_11_14 n_11_14_h n_11_14 {Rvia_cell}
RVia_11_15 n_11_15_h n_11_15 {Rvia_cell}
RVia_11_16 n_11_16_h n_11_16 {Rvia_cell}
RVia_12_1 n_12_1_h n_12_1 {Rvia_cell}
RVia_12_2 n_12_2_h n_12_2 {Rvia_cell}
RVia_12_3 n_12_3_h n_12_3 {Rvia_cell}
RVia_12_4 n_12_4_h n_12_4 {Rvia_cell}
RVia_12_5 n_12_5_h n_12_5 {Rvia_cell}
RVia_12_6 n_12_6_h n_12_6 {Rvia_cell}
RVia_12_7 n_12_7_h n_12_7 {Rvia_cell}
RVia_12_8 n_12_8_h n_12_8 {Rvia_cell}
RVia_12_9 n_12_9_h n_12_9 {Rvia_cell}
RVia_12_10 n_12_10_h n_12_10 {Rvia_cell}
RVia_12_11 n_12_11_h n_12_11 {Rvia_cell}
RVia_12_12 n_12_12_h n_12_12 {Rvia_cell}
RVia_12_13 n_12_13_h n_12_13 {Rvia_cell}
RVia_12_14 n_12_14_h n_12_14 {Rvia_cell}
RVia_12_15 n_12_15_h n_12_15 {Rvia_cell}
RVia_12_16 n_12_16_h n_12_16 {Rvia_cell}
RVia_13_1 n_13_1_h n_13_1 {Rvia_cell}
RVia_13_2 n_13_2_h n_13_2 {Rvia_cell}
RVia_13_3 n_13_3_h n_13_3 {Rvia_cell}
RVia_13_4 n_13_4_h n_13_4 {Rvia_cell}
RVia_13_5 n_13_5_h n_13_5 {Rvia_cell}
RVia_13_6 n_13_6_h n_13_6 {Rvia_cell}
RVia_13_7 n_13_7_h n_13_7 {Rvia_cell}
RVia_13_8 n_13_8_h n_13_8 {Rvia_cell}
RVia_13_9 n_13_9_h n_13_9 {Rvia_cell}
RVia_13_10 n_13_10_h n_13_10 {Rvia_cell}
RVia_13_11 n_13_11_h n_13_11 {Rvia_cell}
RVia_13_12 n_13_12_h n_13_12 {Rvia_cell}
RVia_13_13 n_13_13_h n_13_13 {Rvia_cell}
RVia_13_14 n_13_14_h n_13_14 {Rvia_cell}
RVia_13_15 n_13_15_h n_13_15 {Rvia_cell}
RVia_13_16 n_13_16_h n_13_16 {Rvia_cell}
RVia_14_1 n_14_1_h n_14_1 {Rvia_cell}
RVia_14_2 n_14_2_h n_14_2 {Rvia_cell}
RVia_14_3 n_14_3_h n_14_3 {Rvia_cell}
RVia_14_4 n_14_4_h n_14_4 {Rvia_cell}
RVia_14_5 n_14_5_h n_14_5 {Rvia_cell}
RVia_14_6 n_14_6_h n_14_6 {Rvia_cell}
RVia_14_7 n_14_7_h n_14_7 {Rvia_cell}
RVia_14_8 n_14_8_h n_14_8 {Rvia_cell}
RVia_14_9 n_14_9_h n_14_9 {Rvia_cell}
RVia_14_10 n_14_10_h n_14_10 {Rvia_cell}
RVia_14_11 n_14_11_h n_14_11 {Rvia_cell}
RVia_14_12 n_14_12_h n_14_12 {Rvia_cell}
RVia_14_13 n_14_13_h n_14_13 {Rvia_cell}
RVia_14_14 n_14_14_h n_14_14 {Rvia_cell}
RVia_14_15 n_14_15_h n_14_15 {Rvia_cell}
RVia_14_16 n_14_16_h n_14_16 {Rvia_cell}
RVia_15_1 n_15_1_h n_15_1 {Rvia_cell}
RVia_15_2 n_15_2_h n_15_2 {Rvia_cell}
RVia_15_3 n_15_3_h n_15_3 {Rvia_cell}
RVia_15_4 n_15_4_h n_15_4 {Rvia_cell}
RVia_15_5 n_15_5_h n_15_5 {Rvia_cell}
RVia_15_6 n_15_6_h n_15_6 {Rvia_cell}
RVia_15_7 n_15_7_h n_15_7 {Rvia_cell}
RVia_15_8 n_15_8_h n_15_8 {Rvia_cell}
RVia_15_9 n_15_9_h n_15_9 {Rvia_cell}
RVia_15_10 n_15_10_h n_15_10 {Rvia_cell}
RVia_15_11 n_15_11_h n_15_11 {Rvia_cell}
RVia_15_12 n_15_12_h n_15_12 {Rvia_cell}
RVia_15_13 n_15_13_h n_15_13 {Rvia_cell}
RVia_15_14 n_15_14_h n_15_14 {Rvia_cell}
RVia_15_15 n_15_15_h n_15_15 {Rvia_cell}
RVia_15_16 n_15_16_h n_15_16 {Rvia_cell}
RVia_16_1 n_16_1_h n_16_1 {Rvia_cell}
RVia_16_2 n_16_2_h n_16_2 {Rvia_cell}
RVia_16_3 n_16_3_h n_16_3 {Rvia_cell}
RVia_16_4 n_16_4_h n_16_4 {Rvia_cell}
RVia_16_5 n_16_5_h n_16_5 {Rvia_cell}
RVia_16_6 n_16_6_h n_16_6 {Rvia_cell}
RVia_16_7 n_16_7_h n_16_7 {Rvia_cell}
RVia_16_8 n_16_8_h n_16_8 {Rvia_cell}
RVia_16_9 n_16_9_h n_16_9 {Rvia_cell}
RVia_16_10 n_16_10_h n_16_10 {Rvia_cell}
RVia_16_11 n_16_11_h n_16_11 {Rvia_cell}
RVia_16_12 n_16_12_h n_16_12 {Rvia_cell}
RVia_16_13 n_16_13_h n_16_13 {Rvia_cell}
RVia_16_14 n_16_14_h n_16_14 {Rvia_cell}
RVia_16_15 n_16_15_h n_16_15 {Rvia_cell}
RVia_16_16 n_16_16_h n_16_16 {Rvia_cell}

*=========== Current Source Loads ===========
Ic_1_1 n_1_1 0 {Iload/Ncells}
Ic_1_2 n_1_2 0 {Iload/Ncells}
Ic_1_3 n_1_3 0 {Iload/Ncells}
Ic_1_4 n_1_4 0 {Iload/Ncells}
Ic_1_5 n_1_5 0 {Iload/Ncells}
Ic_1_6 n_1_6 0 {Iload/Ncells}
Ic_1_7 n_1_7 0 {Iload/Ncells}
Ic_1_8 n_1_8 0 {Iload/Ncells}
Ic_1_9 n_1_9 0 {Iload/Ncells}
Ic_1_10 n_1_10 0 {Iload/Ncells}
Ic_1_11 n_1_11 0 {Iload/Ncells}
Ic_1_12 n_1_12 0 {Iload/Ncells}
Ic_1_13 n_1_13 0 {Iload/Ncells}
Ic_1_14 n_1_14 0 {Iload/Ncells}
Ic_1_15 n_1_15 0 {Iload/Ncells}
Ic_1_16 n_1_16 0 {Iload/Ncells}
Ic_2_1 n_2_1 0 {Iload/Ncells}
Ic_2_2 n_2_2 0 {Iload/Ncells}
Ic_2_3 n_2_3 0 {Iload/Ncells}
Ic_2_4 n_2_4 0 {Iload/Ncells}
Ic_2_5 n_2_5 0 {Iload/Ncells}
Ic_2_6 n_2_6 0 {Iload/Ncells}
Ic_2_7 n_2_7 0 {Iload/Ncells}
Ic_2_8 n_2_8 0 {Iload/Ncells}
Ic_2_9 n_2_9 0 {Iload/Ncells}
Ic_2_10 n_2_10 0 {Iload/Ncells}
Ic_2_11 n_2_11 0 {Iload/Ncells}
Ic_2_12 n_2_12 0 {Iload/Ncells}
Ic_2_13 n_2_13 0 {Iload/Ncells}
Ic_2_14 n_2_14 0 {Iload/Ncells}
Ic_2_15 n_2_15 0 {Iload/Ncells}
Ic_2_16 n_2_16 0 {Iload/Ncells}
Ic_3_1 n_3_1 0 {Iload/Ncells}
Ic_3_2 n_3_2 0 {Iload/Ncells}
Ic_3_3 n_3_3 0 {Iload/Ncells}
Ic_3_4 n_3_4 0 {Iload/Ncells}
Ic_3_5 n_3_5 0 {Iload/Ncells}
Ic_3_6 n_3_6 0 {Iload/Ncells}
Ic_3_7 n_3_7 0 {Iload/Ncells}
Ic_3_8 n_3_8 0 {Iload/Ncells}
Ic_3_9 n_3_9 0 {Iload/Ncells}
Ic_3_10 n_3_10 0 {Iload/Ncells}
Ic_3_11 n_3_11 0 {Iload/Ncells}
Ic_3_12 n_3_12 0 {Iload/Ncells}
Ic_3_13 n_3_13 0 {Iload/Ncells}
Ic_3_14 n_3_14 0 {Iload/Ncells}
Ic_3_15 n_3_15 0 {Iload/Ncells}
Ic_3_16 n_3_16 0 {Iload/Ncells}
Ic_4_1 n_4_1 0 {Iload/Ncells}
Ic_4_2 n_4_2 0 {Iload/Ncells}
Ic_4_3 n_4_3 0 {Iload/Ncells}
Ic_4_4 n_4_4 0 {Iload/Ncells}
Ic_4_5 n_4_5 0 {Iload/Ncells}
Ic_4_6 n_4_6 0 {Iload/Ncells}
Ic_4_7 n_4_7 0 {Iload/Ncells}
Ic_4_8 n_4_8 0 {Iload/Ncells}
Ic_4_9 n_4_9 0 {Iload/Ncells}
Ic_4_10 n_4_10 0 {Iload/Ncells}
Ic_4_11 n_4_11 0 {Iload/Ncells}
Ic_4_12 n_4_12 0 {Iload/Ncells}
Ic_4_13 n_4_13 0 {Iload/Ncells}
Ic_4_14 n_4_14 0 {Iload/Ncells}
Ic_4_15 n_4_15 0 {Iload/Ncells}
Ic_4_16 n_4_16 0 {Iload/Ncells}
Ic_5_1 n_5_1 0 {Iload/Ncells}
Ic_5_2 n_5_2 0 {Iload/Ncells}
Ic_5_3 n_5_3 0 {Iload/Ncells}
Ic_5_4 n_5_4 0 {Iload/Ncells}
Ic_5_5 n_5_5 0 {Iload/Ncells}
Ic_5_6 n_5_6 0 {Iload/Ncells}
Ic_5_7 n_5_7 0 {Iload/Ncells}
Ic_5_8 n_5_8 0 {Iload/Ncells}
Ic_5_9 n_5_9 0 {Iload/Ncells}
Ic_5_10 n_5_10 0 {Iload/Ncells}
Ic_5_11 n_5_11 0 {Iload/Ncells}
Ic_5_12 n_5_12 0 {Iload/Ncells}
Ic_5_13 n_5_13 0 {Iload/Ncells}
Ic_5_14 n_5_14 0 {Iload/Ncells}
Ic_5_15 n_5_15 0 {Iload/Ncells}
Ic_5_16 n_5_16 0 {Iload/Ncells}
Ic_6_1 n_6_1 0 {Iload/Ncells}
Ic_6_2 n_6_2 0 {Iload/Ncells}
Ic_6_3 n_6_3 0 {Iload/Ncells}
Ic_6_4 n_6_4 0 {Iload/Ncells}
Ic_6_5 n_6_5 0 {Iload/Ncells}
Ic_6_6 n_6_6 0 {Iload/Ncells}
Ic_6_7 n_6_7 0 {Iload/Ncells}
Ic_6_8 n_6_8 0 {Iload/Ncells}
Ic_6_9 n_6_9 0 {Iload/Ncells}
Ic_6_10 n_6_10 0 {Iload/Ncells}
Ic_6_11 n_6_11 0 {Iload/Ncells}
Ic_6_12 n_6_12 0 {Iload/Ncells}
Ic_6_13 n_6_13 0 {Iload/Ncells}
Ic_6_14 n_6_14 0 {Iload/Ncells}
Ic_6_15 n_6_15 0 {Iload/Ncells}
Ic_6_16 n_6_16 0 {Iload/Ncells}
Ic_7_1 n_7_1 0 {Iload/Ncells}
Ic_7_2 n_7_2 0 {Iload/Ncells}
Ic_7_3 n_7_3 0 {Iload/Ncells}
Ic_7_4 n_7_4 0 {Iload/Ncells}
Ic_7_5 n_7_5 0 {Iload/Ncells}
Ic_7_6 n_7_6 0 {Iload/Ncells}
Ic_7_7 n_7_7 0 {Iload/Ncells}
Ic_7_8 n_7_8 0 {Iload/Ncells}
Ic_7_9 n_7_9 0 {Iload/Ncells}
Ic_7_10 n_7_10 0 {Iload/Ncells}
Ic_7_11 n_7_11 0 {Iload/Ncells}
Ic_7_12 n_7_12 0 {Iload/Ncells}
Ic_7_13 n_7_13 0 {Iload/Ncells}
Ic_7_14 n_7_14 0 {Iload/Ncells}
Ic_7_15 n_7_15 0 {Iload/Ncells}
Ic_7_16 n_7_16 0 {Iload/Ncells}
Ic_8_1 n_8_1 0 {Iload/Ncells}
Ic_8_2 n_8_2 0 {Iload/Ncells}
Ic_8_3 n_8_3 0 {Iload/Ncells}
Ic_8_4 n_8_4 0 {Iload/Ncells}
Ic_8_5 n_8_5 0 {Iload/Ncells}
Ic_8_6 n_8_6 0 {Iload/Ncells}
Ic_8_7 n_8_7 0 {Iload/Ncells}
Ic_8_8 n_8_8 0 {Iload/Ncells}
Ic_8_9 n_8_9 0 {Iload/Ncells}
Ic_8_10 n_8_10 0 {Iload/Ncells}
Ic_8_11 n_8_11 0 {Iload/Ncells}
Ic_8_12 n_8_12 0 {Iload/Ncells}
Ic_8_13 n_8_13 0 {Iload/Ncells}
Ic_8_14 n_8_14 0 {Iload/Ncells}
Ic_8_15 n_8_15 0 {Iload/Ncells}
Ic_8_16 n_8_16 0 {Iload/Ncells}
Ic_9_1 n_9_1 0 {Iload/Ncells}
Ic_9_2 n_9_2 0 {Iload/Ncells}
Ic_9_3 n_9_3 0 {Iload/Ncells}
Ic_9_4 n_9_4 0 {Iload/Ncells}
Ic_9_5 n_9_5 0 {Iload/Ncells}
Ic_9_6 n_9_6 0 {Iload/Ncells}
Ic_9_7 n_9_7 0 {Iload/Ncells}
Ic_9_8 n_9_8 0 {Iload/Ncells}
Ic_9_9 n_9_9 0 {Iload/Ncells}
Ic_9_10 n_9_10 0 {Iload/Ncells}
Ic_9_11 n_9_11 0 {Iload/Ncells}
Ic_9_12 n_9_12 0 {Iload/Ncells}
Ic_9_13 n_9_13 0 {Iload/Ncells}
Ic_9_14 n_9_14 0 {Iload/Ncells}
Ic_9_15 n_9_15 0 {Iload/Ncells}
Ic_9_16 n_9_16 0 {Iload/Ncells}
Ic_10_1 n_10_1 0 {Iload/Ncells}
Ic_10_2 n_10_2 0 {Iload/Ncells}
Ic_10_3 n_10_3 0 {Iload/Ncells}
Ic_10_4 n_10_4 0 {Iload/Ncells}
Ic_10_5 n_10_5 0 {Iload/Ncells}
Ic_10_6 n_10_6 0 {Iload/Ncells}
Ic_10_7 n_10_7 0 {Iload/Ncells}
Ic_10_8 n_10_8 0 {Iload/Ncells}
Ic_10_9 n_10_9 0 {Iload/Ncells}
Ic_10_10 n_10_10 0 {Iload/Ncells}
Ic_10_11 n_10_11 0 {Iload/Ncells}
Ic_10_12 n_10_12 0 {Iload/Ncells}
Ic_10_13 n_10_13 0 {Iload/Ncells}
Ic_10_14 n_10_14 0 {Iload/Ncells}
Ic_10_15 n_10_15 0 {Iload/Ncells}
Ic_10_16 n_10_16 0 {Iload/Ncells}
Ic_11_1 n_11_1 0 {Iload/Ncells}
Ic_11_2 n_11_2 0 {Iload/Ncells}
Ic_11_3 n_11_3 0 {Iload/Ncells}
Ic_11_4 n_11_4 0 {Iload/Ncells}
Ic_11_5 n_11_5 0 {Iload/Ncells}
Ic_11_6 n_11_6 0 {Iload/Ncells}
Ic_11_7 n_11_7 0 {Iload/Ncells}
Ic_11_8 n_11_8 0 {Iload/Ncells}
Ic_11_9 n_11_9 0 {Iload/Ncells}
Ic_11_10 n_11_10 0 {Iload/Ncells}
Ic_11_11 n_11_11 0 {Iload/Ncells}
Ic_11_12 n_11_12 0 {Iload/Ncells}
Ic_11_13 n_11_13 0 {Iload/Ncells}
Ic_11_14 n_11_14 0 {Iload/Ncells}
Ic_11_15 n_11_15 0 {Iload/Ncells}
Ic_11_16 n_11_16 0 {Iload/Ncells}
Ic_12_1 n_12_1 0 {Iload/Ncells}
Ic_12_2 n_12_2 0 {Iload/Ncells}
Ic_12_3 n_12_3 0 {Iload/Ncells}
Ic_12_4 n_12_4 0 {Iload/Ncells}
Ic_12_5 n_12_5 0 {Iload/Ncells}
Ic_12_6 n_12_6 0 {Iload/Ncells}
Ic_12_7 n_12_7 0 {Iload/Ncells}
Ic_12_8 n_12_8 0 {Iload/Ncells}
Ic_12_9 n_12_9 0 {Iload/Ncells}
Ic_12_10 n_12_10 0 {Iload/Ncells}
Ic_12_11 n_12_11 0 {Iload/Ncells}
Ic_12_12 n_12_12 0 {Iload/Ncells}
Ic_12_13 n_12_13 0 {Iload/Ncells}
Ic_12_14 n_12_14 0 {Iload/Ncells}
Ic_12_15 n_12_15 0 {Iload/Ncells}
Ic_12_16 n_12_16 0 {Iload/Ncells}
Ic_13_1 n_13_1 0 {Iload/Ncells}
Ic_13_2 n_13_2 0 {Iload/Ncells}
Ic_13_3 n_13_3 0 {Iload/Ncells}
Ic_13_4 n_13_4 0 {Iload/Ncells}
Ic_13_5 n_13_5 0 {Iload/Ncells}
Ic_13_6 n_13_6 0 {Iload/Ncells}
Ic_13_7 n_13_7 0 {Iload/Ncells}
Ic_13_8 n_13_8 0 {Iload/Ncells}
Ic_13_9 n_13_9 0 {Iload/Ncells}
Ic_13_10 n_13_10 0 {Iload/Ncells}
Ic_13_11 n_13_11 0 {Iload/Ncells}
Ic_13_12 n_13_12 0 {Iload/Ncells}
Ic_13_13 n_13_13 0 {Iload/Ncells}
Ic_13_14 n_13_14 0 {Iload/Ncells}
Ic_13_15 n_13_15 0 {Iload/Ncells}
Ic_13_16 n_13_16 0 {Iload/Ncells}
Ic_14_1 n_14_1 0 {Iload/Ncells}
Ic_14_2 n_14_2 0 {Iload/Ncells}
Ic_14_3 n_14_3 0 {Iload/Ncells}
Ic_14_4 n_14_4 0 {Iload/Ncells}
Ic_14_5 n_14_5 0 {Iload/Ncells}
Ic_14_6 n_14_6 0 {Iload/Ncells}
Ic_14_7 n_14_7 0 {Iload/Ncells}
Ic_14_8 n_14_8 0 {Iload/Ncells}
Ic_14_9 n_14_9 0 {Iload/Ncells}
Ic_14_10 n_14_10 0 {Iload/Ncells}
Ic_14_11 n_14_11 0 {Iload/Ncells}
Ic_14_12 n_14_12 0 {Iload/Ncells}
Ic_14_13 n_14_13 0 {Iload/Ncells}
Ic_14_14 n_14_14 0 {Iload/Ncells}
Ic_14_15 n_14_15 0 {Iload/Ncells}
Ic_14_16 n_14_16 0 {Iload/Ncells}
Ic_15_1 n_15_1 0 {Iload/Ncells}
Ic_15_2 n_15_2 0 {Iload/Ncells}
Ic_15_3 n_15_3 0 {Iload/Ncells}
Ic_15_4 n_15_4 0 {Iload/Ncells}
Ic_15_5 n_15_5 0 {Iload/Ncells}
Ic_15_6 n_15_6 0 {Iload/Ncells}
Ic_15_7 n_15_7 0 {Iload/Ncells}
Ic_15_8 n_15_8 0 {Iload/Ncells}
Ic_15_9 n_15_9 0 {Iload/Ncells}
Ic_15_10 n_15_10 0 {Iload/Ncells}
Ic_15_11 n_15_11 0 {Iload/Ncells}
Ic_15_12 n_15_12 0 {Iload/Ncells}
Ic_15_13 n_15_13 0 {Iload/Ncells}
Ic_15_14 n_15_14 0 {Iload/Ncells}
Ic_15_15 n_15_15 0 {Iload/Ncells}
Ic_15_16 n_15_16 0 {Iload/Ncells}
Ic_16_1 n_16_1 0 {Iload/Ncells}
Ic_16_2 n_16_2 0 {Iload/Ncells}
Ic_16_3 n_16_3 0 {Iload/Ncells}
Ic_16_4 n_16_4 0 {Iload/Ncells}
Ic_16_5 n_16_5 0 {Iload/Ncells}
Ic_16_6 n_16_6 0 {Iload/Ncells}
Ic_16_7 n_16_7 0 {Iload/Ncells}
Ic_16_8 n_16_8 0 {Iload/Ncells}
Ic_16_9 n_16_9 0 {Iload/Ncells}
Ic_16_10 n_16_10 0 {Iload/Ncells}
Ic_16_11 n_16_11 0 {Iload/Ncells}
Ic_16_12 n_16_12 0 {Iload/Ncells}
Ic_16_13 n_16_13 0 {Iload/Ncells}
Ic_16_14 n_16_14 0 {Iload/Ncells}
Ic_16_15 n_16_15 0 {Iload/Ncells}
Ic_16_16 n_16_16 0 {Iload/Ncells}

*=========== Supply Stacks (4 corners) ===========
RSup_1 Vout n_1_1_h {Rsup}
RSup_2 Vout n_1_16_h {Rsup}
RSup_3 Vout n_16_1_h {Rsup}
RSup_4 Vout n_16_16_h {Rsup}

*=========== Standalone Analysis ===========
Vsupply Vout 0 0.6
.op
.end
